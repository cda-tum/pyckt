.suckt  complementary_op_amp31 ibias in1 in2 out source_nmos source_pmos
M1 net_0 in1 net_1 net_1 pmos
M2 net_2 in2 net_1 net_1 pmos
M3 net_3 in1 net_4 net_4 nmos
M4 net_5 in2 net_4 net_4 nmos
M5 net_0 bias_n_1b source_nmos source_nmos nmos
M6 net_7 ibias net_0 net_0 nmos
M7 net_2 bias_n_1b source_nmos source_nmos nmos
M8 out ibias net_2 net_2 nmos
M9 net_3 net_7 source_pmos source_pmos pmos
M10 net_7 bias_p_2 net_3 net_3 pmos
M11 net_5 net_7 source_pmos source_pmos pmos
M12 out bias_p_2 net_5 net_5 pmos
M13 net_10 bias_n_1b source_nmos source_nmos nmos
M14 net_4 ibias net_10 net_10 nmos
M15 net_13 bias_p_3 source_pmos source_pmos pmos
M16 net_1 bias_p_2 net_13 net_13 pmos
M17 bias_n_1b bias_n_1b source_nmos source_nmos nmos
M18 ibias ibias bias_n_1b bias_n_1b nmos
M19 bias_p_2 bias_p_2 source_pmos source_pmos pmos
M20 bias_p_3 bias_p_3 source_pmos source_pmos pmos
M21 bias_p_3 bias_n_1b source_nmos source_nmos nmos
M22 bias_p_2 bias_n_1b source_nmos source_nmos nmos
Cap_load_1 out source_nmos
.end complementary_op_amp31
