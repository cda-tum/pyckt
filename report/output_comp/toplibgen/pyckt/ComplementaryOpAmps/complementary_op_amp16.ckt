.suckt  complementary_op_amp16 ibias in1 in2 out source_nmos source_pmos
M1 net_0 in1 net_1 net_1 pmos
M2 net_2 in2 net_1 net_1 pmos
M3 net_3 in1 net_4 net_4 nmos
M4 net_5 in2 net_4 net_4 nmos
M5 net_3 net_6 source_pmos source_pmos pmos
M6 net_6 bias_p_4 net_3 net_3 pmos
M7 net_5 net_6 source_pmos source_pmos pmos
M8 out bias_p_4 net_5 net_5 pmos
M9 net_0 net_6 source_nmos source_nmos nmos
M10 net_6 bias_n_2 net_0 net_0 nmos
M11 net_2 net_6 source_nmos source_nmos nmos
M12 out bias_n_2 net_2 net_2 nmos
M13 net_9 net_9 source_nmos source_nmos nmos
M14 net_4 net_10 net_9 net_9 nmos
M15 net_11 net_11 source_pmos source_pmos pmos
M16 net_1 ibias net_11 net_11 pmos
M17 net_10 net_10 bias_n_1m bias_n_1m nmos
M18 bias_n_1m net_9 source_nmos source_nmos nmos
M19 bias_n_2 bias_n_2 source_nmos source_nmos nmos
M20 ibias ibias bias_p_3m bias_p_3m pmos
M21 bias_p_3m net_11 source_pmos source_pmos pmos
M22 bias_p_4 bias_p_4 source_pmos source_pmos pmos
M23 bias_n_5 bias_n_5 source_nmos source_nmos nmos
M24 net_10 net_11 source_pmos source_pmos pmos
M25 bias_n_2 net_11 source_pmos source_pmos pmos
M26 bias_p_4 bias_n_5 source_nmos source_nmos nmos
M27 bias_n_5 net_11 source_pmos source_pmos pmos
Cap_load_1 out source_nmos
.end complementary_op_amp16
