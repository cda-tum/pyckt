.suckt  complementary_op_amp32 ibias in1 in2 out source_nmos source_pmos
M1 net_0 in1 net_1 net_1 pmos
M2 net_2 in2 net_1 net_1 pmos
M3 net_3 in1 net_4 net_4 nmos
M4 net_5 in2 net_4 net_4 nmos
M5 net_0 bias_n_2b source_nmos source_nmos nmos
M6 net_7 bias_n_2t net_0 net_0 nmos
M7 net_2 bias_n_2b source_nmos source_nmos nmos
M8 out bias_n_2t net_2 net_2 nmos
M9 net_3 net_7 source_pmos source_pmos pmos
M10 net_7 bias_p_4 net_3 net_3 pmos
M11 net_5 net_7 source_pmos source_pmos pmos
M12 out bias_p_4 net_5 net_5 pmos
M13 net_10 net_10 source_nmos source_nmos nmos
M14 net_4 net_11 net_10 net_10 nmos
M15 net_12 net_12 source_pmos source_pmos pmos
M16 net_1 ibias net_12 net_12 pmos
M17 net_11 net_11 bias_n_1m bias_n_1m nmos
M18 bias_n_1m net_10 source_nmos source_nmos nmos
M19 bias_n_2b bias_n_2b source_nmos source_nmos nmos
M20 bias_n_2t bias_n_2t bias_n_2b bias_n_2b nmos
M21 ibias ibias bias_p_3m bias_p_3m pmos
M22 bias_p_3m net_12 source_pmos source_pmos pmos
M23 bias_p_4 bias_p_4 source_pmos source_pmos pmos
M24 bias_n_2t net_12 source_pmos source_pmos pmos
M25 bias_p_4 bias_n_2b source_nmos source_nmos nmos
M26 net_11 net_12 source_pmos source_pmos pmos
Cap_load_1 out source_nmos
.end complementary_op_amp32
