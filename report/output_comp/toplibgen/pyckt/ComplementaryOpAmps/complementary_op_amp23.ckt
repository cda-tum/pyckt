.suckt  complementary_op_amp23 ibias in1 in2 out source_nmos source_pmos
M1 net_0 in1 net_1 net_1 pmos
M2 net_2 in2 net_1 net_1 pmos
M3 net_3 in1 net_4 net_4 nmos
M4 net_5 in2 net_4 net_4 nmos
M5 net_3 bias_p_3b source_pmos source_pmos pmos
M6 net_7 ibias net_3 net_3 pmos
M7 net_5 bias_p_3b source_pmos source_pmos pmos
M8 out ibias net_5 net_5 pmos
M9 net_0 net_7 source_nmos source_nmos nmos
M10 net_7 bias_n_1 net_0 net_0 nmos
M11 net_2 net_7 source_nmos source_nmos nmos
M12 out bias_n_1 net_2 net_2 nmos
M13 net_10 bias_n_2 source_nmos source_nmos nmos
M14 net_4 bias_n_1 net_10 net_10 nmos
M15 net_13 bias_p_3b source_pmos source_pmos pmos
M16 net_1 ibias net_13 net_13 pmos
M17 bias_n_1 bias_n_1 source_nmos source_nmos nmos
M18 bias_n_2 bias_n_2 source_nmos source_nmos nmos
M19 bias_p_3b bias_p_3b source_pmos source_pmos pmos
M20 ibias ibias bias_p_3b bias_p_3b pmos
M21 bias_n_2 bias_p_3b source_pmos source_pmos pmos
M22 bias_n_1 bias_p_3b source_pmos source_pmos pmos
Cap_load_1 out source_nmos
.end complementary_op_amp23
