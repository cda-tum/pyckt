.suckt  complementary_op_amp28 ibias in1 in2 out source_nmos source_pmos
M1 net_0 in1 net_1 net_1 pmos
M2 net_2 in2 net_1 net_1 pmos
M3 net_3 in1 net_4 net_4 nmos
M4 net_5 in2 net_4 net_4 nmos
M5 net_3 bias_p_3b source_pmos source_pmos pmos
M6 net_7 bias_p_3t net_3 net_3 pmos
M7 net_5 bias_p_3b source_pmos source_pmos pmos
M8 out bias_p_3t net_5 net_5 pmos
M9 net_0 net_7 source_nmos source_nmos nmos
M10 net_7 net_7 net_0 net_0 nmos
M11 net_2 net_7 source_nmos source_nmos nmos
M12 out net_7 net_2 net_2 nmos
M13 net_9 net_9 source_nmos source_nmos nmos
M14 net_4 ibias net_9 net_9 nmos
M15 net_11 net_11 source_pmos source_pmos pmos
M16 net_1 net_12 net_11 net_11 pmos
M17 ibias ibias bias_n_1m bias_n_1m nmos
M18 bias_n_1m net_9 source_nmos source_nmos nmos
M19 net_12 net_12 bias_p_2m bias_p_2m pmos
M20 bias_p_2m net_11 source_pmos source_pmos pmos
M21 bias_p_3b bias_p_3b source_pmos source_pmos pmos
M22 bias_p_3t bias_p_3t bias_p_3b bias_p_3b pmos
M23 bias_p_3t net_9 source_nmos source_nmos nmos
M24 net_12 net_9 source_nmos source_nmos nmos
Cap_load_1 out source_nmos
.end complementary_op_amp28
