.suckt  complementary_op_amp5 ibias in1 in2 out source_nmos source_pmos
M1 net_0 in1 net_1 net_1 pmos
M2 net_2 in2 net_1 net_1 pmos
M3 net_3 in1 net_4 net_4 nmos
M4 net_5 in2 net_4 net_4 nmos
M5 net_3 bias_p_3 source_pmos source_pmos pmos
M6 net_7 bias_p_2 net_3 net_3 pmos
M7 net_5 bias_p_3 source_pmos source_pmos pmos
M8 out bias_p_2 net_5 net_5 pmos
M9 net_0 net_0 source_nmos source_nmos nmos
M10 net_7 net_7 net_0 net_0 nmos
M11 net_2 net_0 source_nmos source_nmos nmos
M12 out net_7 net_2 net_2 nmos
M13 net_4 ibias source_nmos source_nmos nmos
M14 net_1 bias_p_3 source_pmos source_pmos pmos
M15 ibias ibias source_nmos source_nmos nmos
M16 bias_p_2 bias_p_2 source_pmos source_pmos pmos
M17 bias_p_3 bias_p_3 source_pmos source_pmos pmos
M18 bias_p_3 ibias source_nmos source_nmos nmos
M19 bias_p_2 ibias source_nmos source_nmos nmos
Cap_load_1 out source_nmos
.end complementary_op_amp5
