.suckt  complementary_op_amp2 ibias in1 in2 out source_nmos source_pmos
M1 net_0 in1 net_1 net_1 pmos
M2 net_2 in2 net_1 net_1 pmos
M3 net_3 in1 net_4 net_4 nmos
M4 net_5 in2 net_4 net_4 nmos
M5 net_3 net_6 source_pmos source_pmos pmos
M6 net_6 bias_p_3 net_3 net_3 pmos
M7 net_5 net_6 source_pmos source_pmos pmos
M8 out bias_p_3 net_5 net_5 pmos
M9 net_0 net_6 source_nmos source_nmos nmos
M10 net_6 bias_n_1 net_0 net_0 nmos
M11 net_2 net_6 source_nmos source_nmos nmos
M12 out bias_n_1 net_2 net_2 nmos
M13 net_4 bias_n_2 source_nmos source_nmos nmos
M14 net_1 ibias source_pmos source_pmos pmos
M15 bias_n_1 bias_n_1 source_nmos source_nmos nmos
M16 bias_n_2 bias_n_2 source_nmos source_nmos nmos
M17 bias_p_3 bias_p_3 source_pmos source_pmos pmos
M18 ibias ibias source_pmos source_pmos pmos
M19 bias_n_2 ibias source_pmos source_pmos pmos
M20 bias_n_1 ibias source_pmos source_pmos pmos
M21 bias_p_3 bias_n_2 source_nmos source_nmos nmos
Cap_load_1 out source_nmos
.end complementary_op_amp2
