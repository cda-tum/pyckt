.suckt  two_stage_fully_differential_op_amp486 ibias in1 in2 out source_nmos source_pmos
M1 net_0 in1 net_1 net_1 pmos
M2 net_2 in2 net_1 net_1 pmos
M3 out1firststage net_3 net_0 net_0 pmos
M4 out2firststage net_3 net_2 net_2 pmos
M5 out1firststage outfeedback source_nmos source_nmos nmos
M6 out2firststage outfeedback source_nmos source_nmos nmos
M7 net_4 ibias source_pmos source_pmos pmos
M8 net_1 bias_p_4 net_4 net_4 pmos
M9 net_7 out2 net_8 net_8 pmos
M10 outfeedback vref net_8 net_8 pmos
M11 net_7 out1 net_9 net_9 pmos
M12 outfeedback vref net_9 net_9 pmos
M13 net_7 net_7 source_nmos source_nmos nmos
M14 outfeedback outfeedback source_nmos source_nmos nmos
M15 net_8 ibias source_pmos source_pmos pmos
M16 net_9 ibias source_pmos source_pmos pmos
M17 net_11 net_11 source_pmos source_pmos pmos
M18 out1 net_12 net_11 net_11 pmos
M19 net_13 out1firststage source_nmos source_nmos nmos
M20 out1 bias_n_1 net_13 net_13 nmos
M21 net_15 net_15 source_pmos source_pmos pmos
M22 out2 net_16 net_15 net_15 pmos
M23 net_17 out2firststage source_nmos source_nmos nmos
M24 out2 bias_n_1 net_17 net_17 nmos
M25 bias_n_1 bias_n_1 source_nmos source_nmos nmos
M26 net_3 net_3 net_1 net_1 pmos
M27 net_12 net_12 bias_p_2m bias_p_2m pmos
M28 bias_p_2m net_11 source_pmos source_pmos pmos
M29 net_16 net_16 bias_p_3m bias_p_3m pmos
M30 bias_p_3m net_15 source_pmos source_pmos pmos
M31 bias_p_4 bias_p_4 source_pmos source_pmos pmos
M32 ibias ibias source_pmos source_pmos pmos
M33 bias_n_6 bias_n_6 source_nmos source_nmos nmos
M34 bias_n_1 ibias source_pmos source_pmos pmos
M35 net_3 bias_n_6 source_nmos source_nmos nmos
M36 bias_p_4 bias_n_6 source_nmos source_nmos nmos
M37 net_12 bias_n_6 source_nmos source_nmos nmos
M38 net_16 bias_n_6 source_nmos source_nmos nmos
M39 bias_n_6 ibias source_pmos source_pmos pmos
Cap_load_1 out1 source_nmos
Cap_load_2 out2 source_nmos
Cap_compensation_1 out1firststage out1
Cap_compensation_2 out2firststage out2
.end two_stage_fully_differential_op_amp486
