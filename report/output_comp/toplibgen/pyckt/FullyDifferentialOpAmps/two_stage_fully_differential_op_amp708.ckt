.suckt  two_stage_fully_differential_op_amp708 ibias in1 in2 out source_nmos source_pmos
M1 net_0 in1 net_1 net_1 nmos
M2 net_2 in2 net_1 net_1 nmos
M3 net_0 outfeedback source_pmos source_pmos pmos
M4 out1firststage bias_p_5 net_0 net_0 pmos
M5 net_2 outfeedback source_pmos source_pmos pmos
M6 out2firststage bias_p_5 net_2 net_2 pmos
M7 out1firststage ibias source_nmos source_nmos nmos
M8 out2firststage ibias source_nmos source_nmos nmos
M9 net_5 net_5 source_nmos source_nmos nmos
M10 net_1 net_6 net_5 net_5 nmos
M11 net_7 out2 net_8 net_8 nmos
M12 outfeedback vref net_8 net_8 nmos
M13 net_7 out1 net_9 net_9 nmos
M14 outfeedback vref net_9 net_9 nmos
M15 net_7 net_7 source_pmos source_pmos pmos
M16 outfeedback outfeedback source_pmos source_pmos pmos
M17 net_8 ibias source_nmos source_nmos nmos
M18 net_9 ibias source_nmos source_nmos nmos
M19 net_11 out1firststage source_pmos source_pmos pmos
M20 out1 bias_p_5 net_11 net_11 pmos
M21 net_13 net_13 source_nmos source_nmos nmos
M22 out1 net_14 net_13 net_13 nmos
M23 net_15 out2firststage source_pmos source_pmos pmos
M24 out2 bias_p_5 net_15 net_15 pmos
M25 net_17 net_17 source_nmos source_nmos nmos
M26 out2 net_18 net_17 net_17 nmos
M27 net_6 net_6 bias_n_1m bias_n_1m nmos
M28 bias_n_1m net_5 source_nmos source_nmos nmos
M29 net_14 net_14 bias_n_2m bias_n_2m nmos
M30 bias_n_2m net_13 source_nmos source_nmos nmos
M31 net_18 net_18 bias_n_3m bias_n_3m nmos
M32 bias_n_3m net_17 source_nmos source_nmos nmos
M33 ibias ibias source_nmos source_nmos nmos
M34 bias_p_5 bias_p_5 source_pmos source_pmos pmos
M35 bias_p_6 bias_p_6 source_pmos source_pmos pmos
M36 bias_p_5 ibias source_nmos source_nmos nmos
M37 net_6 bias_p_6 source_pmos source_pmos pmos
M38 net_14 bias_p_6 source_pmos source_pmos pmos
M39 net_18 bias_p_6 source_pmos source_pmos pmos
M40 bias_p_6 ibias source_nmos source_nmos nmos
Cap_load_1 out1 source_nmos
Cap_load_2 out2 source_nmos
Cap_compensation_1 out1firststage out1
Cap_compensation_2 out2firststage out2
.end two_stage_fully_differential_op_amp708
