.suckt  one_stage_fully_differential_op_amp42 ibias in1 in2 out source_nmos source_pmos
M1 net_0 in1 net_1 net_1 pmos
M2 net_2 in2 net_1 net_1 pmos
M3 out1 net_3 net_0 net_0 pmos
M4 out2 net_3 net_2 net_2 pmos
M5 out1 outfeedback source_nmos source_nmos nmos
M6 out2 outfeedback source_nmos source_nmos nmos
M7 net_4 bias_p_1b source_pmos source_pmos pmos
M8 net_1 ibias net_4 net_4 pmos
M9 net_7 out2 net_8 net_8 pmos
M10 outfeedback vref net_8 net_8 pmos
M11 net_7 out1 net_9 net_9 pmos
M12 outfeedback vref net_9 net_9 pmos
M13 net_7 net_7 source_nmos source_nmos nmos
M14 outfeedback outfeedback source_nmos source_nmos nmos
M15 net_10 bias_p_1b source_pmos source_pmos pmos
M16 net_8 ibias net_10 net_10 pmos
M17 net_13 bias_p_1b source_pmos source_pmos pmos
M18 net_9 ibias net_13 net_13 pmos
M19 net_3 net_3 net_1 net_1 pmos
M20 bias_p_1b bias_p_1b source_pmos source_pmos pmos
M21 ibias ibias bias_p_1b bias_p_1b pmos
M22 bias_n_2 bias_n_2 source_nmos source_nmos nmos
M23 net_3 bias_n_2 source_nmos source_nmos nmos
M24 bias_n_2 bias_p_1b source_pmos source_pmos pmos
Cap_load_1 out1 source_nmos
Cap_load_2 out2 source_nmos
.end one_stage_fully_differential_op_amp42
