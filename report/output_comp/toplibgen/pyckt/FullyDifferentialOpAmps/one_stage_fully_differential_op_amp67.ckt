.suckt  one_stage_fully_differential_op_amp67 ibias in1 in2 out source_nmos source_pmos
M1 net_0 in1 net_1 net_1 nmos
M2 net_2 in2 net_1 net_1 nmos
M3 out1 net_3 net_0 net_0 nmos
M4 out2 net_3 net_2 net_2 nmos
M5 out1 outfeedback source_pmos source_pmos pmos
M6 out2 outfeedback source_pmos source_pmos pmos
M7 net_4 net_4 source_nmos source_nmos nmos
M8 net_1 net_5 net_4 net_4 nmos
M9 net_6 out2 net_7 net_7 nmos
M10 outfeedback vref net_7 net_7 nmos
M11 net_6 out1 net_8 net_8 nmos
M12 outfeedback vref net_8 net_8 nmos
M13 net_6 net_6 source_pmos source_pmos pmos
M14 outfeedback outfeedback source_pmos source_pmos pmos
M15 net_7 ibias source_nmos source_nmos nmos
M16 net_8 ibias source_nmos source_nmos nmos
M17 net_3 net_3 net_1 net_1 nmos
M18 net_5 net_5 bias_n_1m bias_n_1m nmos
M19 bias_n_1m net_4 source_nmos source_nmos nmos
M20 ibias ibias source_nmos source_nmos nmos
M21 bias_p_3 bias_p_3 source_pmos source_pmos pmos
M22 net_3 bias_p_3 source_pmos source_pmos pmos
M23 net_5 bias_p_3 source_pmos source_pmos pmos
M24 bias_p_3 ibias source_nmos source_nmos nmos
Cap_load_1 out1 source_nmos
Cap_load_2 out2 source_nmos
.end one_stage_fully_differential_op_amp67
