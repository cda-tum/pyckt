.suckt  one_stage_fully_differential_op_amp47 ibias in1 in2 out source_nmos source_pmos
M1 net_0 in1 net_1 net_1 pmos
M2 net_2 in2 net_1 net_1 pmos
M3 out1 net_3 net_0 net_0 pmos
M4 out2 net_3 net_2 net_2 pmos
M5 net_4 outfeedback source_nmos source_nmos nmos
M6 out1 bias_n_1 net_4 net_4 nmos
M7 net_6 outfeedback source_nmos source_nmos nmos
M8 out2 bias_n_1 net_6 net_6 nmos
M9 net_7 net_7 source_pmos source_pmos pmos
M10 net_1 net_8 net_7 net_7 pmos
M11 net_9 out2 net_10 net_10 pmos
M12 outfeedback vref net_10 net_10 pmos
M13 net_9 out1 net_11 net_11 pmos
M14 outfeedback vref net_11 net_11 pmos
M15 net_9 net_9 source_nmos source_nmos nmos
M16 outfeedback outfeedback source_nmos source_nmos nmos
M17 net_10 ibias source_pmos source_pmos pmos
M18 net_11 ibias source_pmos source_pmos pmos
M19 bias_n_1 bias_n_1 source_nmos source_nmos nmos
M20 net_3 net_3 net_1 net_1 pmos
M21 net_8 net_8 bias_p_2m bias_p_2m pmos
M22 bias_p_2m net_7 source_pmos source_pmos pmos
M23 ibias ibias source_pmos source_pmos pmos
M24 bias_n_4 bias_n_4 source_nmos source_nmos nmos
M25 bias_n_1 ibias source_pmos source_pmos pmos
M26 net_3 bias_n_4 source_nmos source_nmos nmos
M27 net_8 bias_n_4 source_nmos source_nmos nmos
M28 bias_n_4 ibias source_pmos source_pmos pmos
Cap_load_1 out1 source_nmos
Cap_load_2 out2 source_nmos
.end one_stage_fully_differential_op_amp47
