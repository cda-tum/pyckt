.suckt  two_stage_fully_differential_op_amp273 ibias in1 in2 out source_nmos source_pmos
M1 net_0 in1 net_1 net_1 nmos
M2 net_2 in2 net_1 net_1 nmos
M3 out1firststage net_3 net_0 net_0 nmos
M4 out2firststage net_3 net_2 net_2 nmos
M5 net_4 outfeedback source_pmos source_pmos pmos
M6 out1firststage bias_p_4 net_4 net_4 pmos
M7 net_6 outfeedback source_pmos source_pmos pmos
M8 out2firststage bias_p_4 net_6 net_6 pmos
M9 net_1 ibias source_nmos source_nmos nmos
M10 net_8 out2 net_9 net_9 nmos
M11 outfeedback vref net_9 net_9 nmos
M12 net_8 out1 net_10 net_10 nmos
M13 outfeedback vref net_10 net_10 nmos
M14 net_8 net_8 source_pmos source_pmos pmos
M15 outfeedback outfeedback source_pmos source_pmos pmos
M16 net_9 ibias source_nmos source_nmos nmos
M17 net_10 ibias source_nmos source_nmos nmos
M18 out1 out1firststage source_pmos source_pmos pmos
M19 net_12 net_12 source_nmos source_nmos nmos
M20 out1 net_13 net_12 net_12 nmos
M21 out2 out2firststage source_pmos source_pmos pmos
M22 net_14 net_14 source_nmos source_nmos nmos
M23 out2 net_15 net_14 net_14 nmos
M24 net_3 net_3 net_1 net_1 nmos
M25 net_13 net_13 bias_n_1m bias_n_1m nmos
M26 bias_n_1m net_12 source_nmos source_nmos nmos
M27 net_15 net_15 bias_n_2m bias_n_2m nmos
M28 bias_n_2m net_14 source_nmos source_nmos nmos
M29 ibias ibias source_nmos source_nmos nmos
M30 bias_p_4 bias_p_4 source_pmos source_pmos pmos
M31 bias_p_5 bias_p_5 source_pmos source_pmos pmos
M32 net_3 bias_p_5 source_pmos source_pmos pmos
M33 bias_p_4 ibias source_nmos source_nmos nmos
M34 net_13 bias_p_5 source_pmos source_pmos pmos
M35 net_15 bias_p_5 source_pmos source_pmos pmos
M36 bias_p_5 ibias source_nmos source_nmos nmos
Cap_load_1 out1 source_nmos
Cap_load_2 out2 source_nmos
Cap_compensation_1 out1firststage out1
Cap_compensation_2 out2firststage out2
.end two_stage_fully_differential_op_amp273
