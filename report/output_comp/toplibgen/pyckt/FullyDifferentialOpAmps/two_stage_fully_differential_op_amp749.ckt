.suckt  two_stage_fully_differential_op_amp749 ibias in1 in2 out source_nmos source_pmos
M1 net_0 in1 net_1 net_1 nmos
M2 net_2 in2 net_1 net_1 nmos
M3 net_0 outfeedback source_pmos source_pmos pmos
M4 out1firststage bias_p_6 net_0 net_0 pmos
M5 net_2 outfeedback source_pmos source_pmos pmos
M6 out2firststage bias_p_6 net_2 net_2 pmos
M7 net_4 ibias source_nmos source_nmos nmos
M8 out1firststage bias_n_2 net_4 net_4 nmos
M9 net_7 ibias source_nmos source_nmos nmos
M10 out2firststage bias_n_2 net_7 net_7 nmos
M11 net_8 net_8 source_nmos source_nmos nmos
M12 net_1 net_9 net_8 net_8 nmos
M13 net_10 out2 net_11 net_11 nmos
M14 outfeedback vref net_11 net_11 nmos
M15 net_10 out1 net_12 net_12 nmos
M16 outfeedback vref net_12 net_12 nmos
M17 net_10 net_10 source_pmos source_pmos pmos
M18 outfeedback outfeedback source_pmos source_pmos pmos
M19 net_11 ibias source_nmos source_nmos nmos
M20 net_12 ibias source_nmos source_nmos nmos
M21 net_14 net_14 source_pmos source_pmos pmos
M22 out1 net_15 net_14 net_14 pmos
M23 out1 out1firststage source_nmos source_nmos nmos
M24 net_16 net_16 source_pmos source_pmos pmos
M25 out2 net_17 net_16 net_16 pmos
M26 out2 out2firststage source_nmos source_nmos nmos
M27 net_9 net_9 bias_n_1m bias_n_1m nmos
M28 bias_n_1m net_8 source_nmos source_nmos nmos
M29 bias_n_2 bias_n_2 source_nmos source_nmos nmos
M30 ibias ibias source_nmos source_nmos nmos
M31 net_15 net_15 bias_p_4m bias_p_4m pmos
M32 bias_p_4m net_14 source_pmos source_pmos pmos
M33 net_17 net_17 bias_p_5m bias_p_5m pmos
M34 bias_p_5m net_16 source_pmos source_pmos pmos
M35 bias_p_6 bias_p_6 source_pmos source_pmos pmos
M36 bias_p_7 bias_p_7 source_pmos source_pmos pmos
M37 net_17 ibias source_nmos source_nmos nmos
M38 bias_n_2 bias_p_7 source_pmos source_pmos pmos
M39 bias_p_6 ibias source_nmos source_nmos nmos
M40 net_9 bias_p_7 source_pmos source_pmos pmos
M41 net_15 ibias source_nmos source_nmos nmos
M42 bias_p_7 ibias source_nmos source_nmos nmos
Cap_load_1 out1 source_nmos
Cap_load_2 out2 source_nmos
Cap_compensation_1 out1firststage out1
Cap_compensation_2 out2firststage out2
.end two_stage_fully_differential_op_amp749
