.suckt  one_stage_fully_differential_op_amp29 ibias in1 in2 out source_nmos source_pmos
M1 out1 in1 net_0 net_0 pmos
M2 out2 in2 net_0 net_0 pmos
M3 net_1 outfeedback source_nmos source_nmos nmos
M4 out1 bias_n_1 net_1 net_1 nmos
M5 net_3 outfeedback source_nmos source_nmos nmos
M6 out2 bias_n_1 net_3 net_3 nmos
M7 net_4 ibias source_pmos source_pmos pmos
M8 net_0 bias_p_2 net_4 net_4 pmos
M9 net_7 out2 net_8 net_8 pmos
M10 outfeedback vref net_8 net_8 pmos
M11 net_7 out1 net_9 net_9 pmos
M12 outfeedback vref net_9 net_9 pmos
M13 net_7 net_7 source_nmos source_nmos nmos
M14 outfeedback outfeedback source_nmos source_nmos nmos
M15 net_8 ibias source_pmos source_pmos pmos
M16 net_9 ibias source_pmos source_pmos pmos
M17 bias_n_1 bias_n_1 source_nmos source_nmos nmos
M18 bias_p_2 bias_p_2 source_pmos source_pmos pmos
M19 ibias ibias source_pmos source_pmos pmos
M20 bias_n_4 bias_n_4 source_nmos source_nmos nmos
M21 bias_n_1 ibias source_pmos source_pmos pmos
M22 bias_p_2 bias_n_4 source_nmos source_nmos nmos
M23 bias_n_4 ibias source_pmos source_pmos pmos
Cap_load_1 out1 source_nmos
Cap_load_2 out2 source_nmos
.end one_stage_fully_differential_op_amp29
