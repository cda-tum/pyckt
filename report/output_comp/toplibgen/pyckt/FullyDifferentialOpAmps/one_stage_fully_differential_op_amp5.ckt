.suckt  one_stage_fully_differential_op_amp5 ibias in1 in2 out source_nmos source_pmos
M1 net_0 in1 net_1 net_1 pmos
M2 net_2 in2 net_1 net_1 pmos
M3 net_0 outfeedback source_nmos source_nmos nmos
M4 out1 bias_n_1 net_0 net_0 nmos
M5 net_2 outfeedback source_nmos source_nmos nmos
M6 out2 bias_n_1 net_2 net_2 nmos
M7 out1 ibias source_pmos source_pmos pmos
M8 out2 ibias source_pmos source_pmos pmos
M9 net_1 ibias source_pmos source_pmos pmos
M10 net_6 out2 net_7 net_7 pmos
M11 outfeedback vref net_7 net_7 pmos
M12 net_6 out1 net_8 net_8 pmos
M13 outfeedback vref net_8 net_8 pmos
M14 net_6 net_6 source_nmos source_nmos nmos
M15 outfeedback outfeedback source_nmos source_nmos nmos
M16 net_7 ibias source_pmos source_pmos pmos
M17 net_8 ibias source_pmos source_pmos pmos
M18 bias_n_1 bias_n_1 source_nmos source_nmos nmos
M19 ibias ibias source_pmos source_pmos pmos
M20 bias_n_1 ibias source_pmos source_pmos pmos
Cap_load_1 out1 source_nmos
Cap_load_2 out2 source_nmos
.end one_stage_fully_differential_op_amp5
