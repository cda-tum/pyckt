.suckt  two_stage_fully_differential_op_amp266 ibias in1 in2 out source_nmos source_pmos
M1 net_0 in1 net_1 net_1 nmos
M2 net_2 in2 net_1 net_1 nmos
M3 out1firststage net_3 net_0 net_0 nmos
M4 out2firststage net_3 net_2 net_2 nmos
M5 net_4 outfeedback source_pmos source_pmos pmos
M6 out1firststage bias_p_3 net_4 net_4 pmos
M7 net_6 outfeedback source_pmos source_pmos pmos
M8 out2firststage bias_p_3 net_6 net_6 pmos
M9 net_1 bias_n_2 source_nmos source_nmos nmos
M10 net_8 out2 net_9 net_9 nmos
M11 outfeedback vref net_9 net_9 nmos
M12 net_8 out1 net_10 net_10 nmos
M13 outfeedback vref net_10 net_10 nmos
M14 net_8 net_8 source_pmos source_pmos pmos
M15 outfeedback outfeedback source_pmos source_pmos pmos
M16 net_9 bias_n_2 source_nmos source_nmos nmos
M17 net_10 bias_n_2 source_nmos source_nmos nmos
M18 out1 ibias source_pmos source_pmos pmos
M19 net_13 out1firststage source_nmos source_nmos nmos
M20 out1 bias_n_1 net_13 net_13 nmos
M21 out2 ibias source_pmos source_pmos pmos
M22 net_16 out2firststage source_nmos source_nmos nmos
M23 out2 bias_n_1 net_16 net_16 nmos
M24 net_3 net_3 net_1 net_1 nmos
M25 bias_n_1 bias_n_1 source_nmos source_nmos nmos
M26 bias_n_2 bias_n_2 source_nmos source_nmos nmos
M27 bias_p_3 bias_p_3 source_pmos source_pmos pmos
M28 ibias ibias source_pmos source_pmos pmos
M29 bias_n_2 ibias source_pmos source_pmos pmos
M30 net_3 ibias source_pmos source_pmos pmos
M31 bias_n_1 ibias source_pmos source_pmos pmos
M32 bias_p_3 bias_n_2 source_nmos source_nmos nmos
Cap_load_1 out1 source_nmos
Cap_load_2 out2 source_nmos
Cap_compensation_1 out1firststage out1
Cap_compensation_2 out2firststage out2
.end two_stage_fully_differential_op_amp266
