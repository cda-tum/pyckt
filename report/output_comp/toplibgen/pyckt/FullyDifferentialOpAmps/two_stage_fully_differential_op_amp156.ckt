.suckt  two_stage_fully_differential_op_amp156 ibias in1 in2 out source_nmos source_pmos
M1 out1firststage in1 net_0 net_0 nmos
M2 out2firststage in2 net_0 net_0 nmos
M3 out1firststage outfeedback source_pmos source_pmos pmos
M4 out2firststage outfeedback source_pmos source_pmos pmos
M5 net_0 ibias source_nmos source_nmos nmos
M6 net_2 out2 net_3 net_3 nmos
M7 outfeedback vref net_3 net_3 nmos
M8 net_2 out1 net_4 net_4 nmos
M9 outfeedback vref net_4 net_4 nmos
M10 net_2 net_2 source_pmos source_pmos pmos
M11 outfeedback outfeedback source_pmos source_pmos pmos
M12 net_3 ibias source_nmos source_nmos nmos
M13 net_4 ibias source_nmos source_nmos nmos
M14 net_6 out1firststage source_pmos source_pmos pmos
M15 out1 bias_p_4 net_6 net_6 pmos
M16 net_8 net_8 source_nmos source_nmos nmos
M17 out1 net_9 net_8 net_8 nmos
M18 net_10 out2firststage source_pmos source_pmos pmos
M19 out2 bias_p_4 net_10 net_10 pmos
M20 net_12 net_12 source_nmos source_nmos nmos
M21 out2 net_13 net_12 net_12 nmos
M22 net_9 net_9 bias_n_1m bias_n_1m nmos
M23 bias_n_1m net_8 source_nmos source_nmos nmos
M24 net_13 net_13 bias_n_2m bias_n_2m nmos
M25 bias_n_2m net_12 source_nmos source_nmos nmos
M26 ibias ibias source_nmos source_nmos nmos
M27 bias_p_4 bias_p_4 source_pmos source_pmos pmos
M28 bias_p_5 bias_p_5 source_pmos source_pmos pmos
M29 bias_p_4 ibias source_nmos source_nmos nmos
M30 net_9 bias_p_5 source_pmos source_pmos pmos
M31 net_13 bias_p_5 source_pmos source_pmos pmos
M32 bias_p_5 ibias source_nmos source_nmos nmos
Cap_load_1 out1 source_nmos
Cap_load_2 out2 source_nmos
Cap_compensation_1 out1firststage out1
Cap_compensation_2 out2firststage out2
.end two_stage_fully_differential_op_amp156
