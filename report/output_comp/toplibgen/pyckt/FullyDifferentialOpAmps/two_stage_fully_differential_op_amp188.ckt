.suckt  two_stage_fully_differential_op_amp188 ibias in1 in2 out source_nmos source_pmos
M1 out1firststage in1 net_0 net_0 nmos
M2 out2firststage in2 net_0 net_0 nmos
M3 net_1 outfeedback source_pmos source_pmos pmos
M4 out1firststage bias_p_3 net_1 net_1 pmos
M5 net_3 outfeedback source_pmos source_pmos pmos
M6 out2firststage bias_p_3 net_3 net_3 pmos
M7 net_0 ibias source_nmos source_nmos nmos
M8 net_5 out2 net_6 net_6 nmos
M9 outfeedback vref net_6 net_6 nmos
M10 net_5 out1 net_7 net_7 nmos
M11 outfeedback vref net_7 net_7 nmos
M12 net_5 net_5 source_pmos source_pmos pmos
M13 outfeedback outfeedback source_pmos source_pmos pmos
M14 net_8 ibias source_nmos source_nmos nmos
M15 net_6 bias_n_1 net_8 net_8 nmos
M16 net_11 ibias source_nmos source_nmos nmos
M17 net_7 bias_n_1 net_11 net_11 nmos
M18 out1 out1firststage source_pmos source_pmos pmos
M19 net_12 ibias source_nmos source_nmos nmos
M20 out1 bias_n_1 net_12 net_12 nmos
M21 out2 out2firststage source_pmos source_pmos pmos
M22 net_15 ibias source_nmos source_nmos nmos
M23 out2 bias_n_1 net_15 net_15 nmos
M24 bias_n_1 bias_n_1 source_nmos source_nmos nmos
M25 ibias ibias source_nmos source_nmos nmos
M26 bias_p_3 bias_p_3 source_pmos source_pmos pmos
M27 bias_p_4 bias_p_4 source_pmos source_pmos pmos
M28 bias_n_1 bias_p_4 source_pmos source_pmos pmos
M29 bias_p_3 ibias source_nmos source_nmos nmos
M30 bias_p_4 ibias source_nmos source_nmos nmos
Cap_load_1 out1 source_nmos
Cap_load_2 out2 source_nmos
Cap_compensation_1 out1firststage out1
Cap_compensation_2 out2firststage out2
.end two_stage_fully_differential_op_amp188
