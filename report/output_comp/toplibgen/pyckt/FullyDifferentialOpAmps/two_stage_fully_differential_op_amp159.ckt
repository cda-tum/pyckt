.suckt  two_stage_fully_differential_op_amp159 ibias in1 in2 out source_nmos source_pmos
M1 out1firststage in1 net_0 net_0 nmos
M2 out2firststage in2 net_0 net_0 nmos
M3 out1firststage outfeedback source_pmos source_pmos pmos
M4 out2firststage outfeedback source_pmos source_pmos pmos
M5 net_0 bias_n_2 source_nmos source_nmos nmos
M6 net_2 out2 net_3 net_3 nmos
M7 outfeedback vref net_3 net_3 nmos
M8 net_2 out1 net_4 net_4 nmos
M9 outfeedback vref net_4 net_4 nmos
M10 net_2 net_2 source_pmos source_pmos pmos
M11 outfeedback outfeedback source_pmos source_pmos pmos
M12 net_5 bias_n_2 source_nmos source_nmos nmos
M13 net_3 bias_n_1 net_5 net_5 nmos
M14 net_8 bias_n_2 source_nmos source_nmos nmos
M15 net_4 bias_n_1 net_8 net_8 nmos
M16 net_9 bias_p_3b source_pmos source_pmos pmos
M17 out1 ibias net_9 net_9 pmos
M18 out1 out1firststage source_nmos source_nmos nmos
M19 net_12 bias_p_3b source_pmos source_pmos pmos
M20 out2 ibias net_12 net_12 pmos
M21 out2 out2firststage source_nmos source_nmos nmos
M22 bias_n_1 bias_n_1 source_nmos source_nmos nmos
M23 bias_n_2 bias_n_2 source_nmos source_nmos nmos
M24 bias_p_3b bias_p_3b source_pmos source_pmos pmos
M25 ibias ibias bias_p_3b bias_p_3b pmos
M26 bias_n_2 bias_p_3b source_pmos source_pmos pmos
M27 bias_n_1 bias_p_3b source_pmos source_pmos pmos
Cap_load_1 out1 source_nmos
Cap_load_2 out2 source_nmos
Cap_compensation_1 out1firststage out1
Cap_compensation_2 out2firststage out2
.end two_stage_fully_differential_op_amp159
