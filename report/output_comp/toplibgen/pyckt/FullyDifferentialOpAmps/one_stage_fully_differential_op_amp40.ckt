.suckt  one_stage_fully_differential_op_amp40 ibias in1 in2 out source_nmos source_pmos
M1 net_0 in1 net_1 net_1 pmos
M2 net_2 in2 net_1 net_1 pmos
M3 net_0 outfeedback source_nmos source_nmos nmos
M4 out1 bias_n_1 net_0 net_0 nmos
M5 net_2 outfeedback source_nmos source_nmos nmos
M6 out2 bias_n_1 net_2 net_2 nmos
M7 net_4 bias_p_3b source_pmos source_pmos pmos
M8 out1 ibias net_4 net_4 pmos
M9 net_7 bias_p_3b source_pmos source_pmos pmos
M10 out2 ibias net_7 net_7 pmos
M11 net_8 net_8 source_pmos source_pmos pmos
M12 net_1 net_9 net_8 net_8 pmos
M13 net_10 out2 net_11 net_11 pmos
M14 outfeedback vref net_11 net_11 pmos
M15 net_10 out1 net_12 net_12 pmos
M16 outfeedback vref net_12 net_12 pmos
M17 net_10 net_10 source_nmos source_nmos nmos
M18 outfeedback outfeedback source_nmos source_nmos nmos
M19 net_13 bias_p_3b source_pmos source_pmos pmos
M20 net_11 ibias net_13 net_13 pmos
M21 net_16 bias_p_3b source_pmos source_pmos pmos
M22 net_12 ibias net_16 net_16 pmos
M23 bias_n_1 bias_n_1 source_nmos source_nmos nmos
M24 net_9 net_9 bias_p_2m bias_p_2m pmos
M25 bias_p_2m net_8 source_pmos source_pmos pmos
M26 bias_p_3b bias_p_3b source_pmos source_pmos pmos
M27 ibias ibias bias_p_3b bias_p_3b pmos
M28 bias_n_4 bias_n_4 source_nmos source_nmos nmos
M29 bias_n_1 bias_p_3b source_pmos source_pmos pmos
M30 net_9 bias_n_4 source_nmos source_nmos nmos
M31 bias_n_4 bias_p_3b source_pmos source_pmos pmos
Cap_load_1 out1 source_nmos
Cap_load_2 out2 source_nmos
.end one_stage_fully_differential_op_amp40
