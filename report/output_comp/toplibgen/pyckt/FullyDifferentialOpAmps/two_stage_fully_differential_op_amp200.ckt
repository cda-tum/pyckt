.suckt  two_stage_fully_differential_op_amp200 ibias in1 in2 out source_nmos source_pmos
M1 net_0 in1 net_1 net_1 nmos
M2 net_2 in2 net_1 net_1 nmos
M3 net_0 outfeedback source_pmos source_pmos pmos
M4 out1firststage bias_p_3 net_0 net_0 pmos
M5 net_2 outfeedback source_pmos source_pmos pmos
M6 out2firststage bias_p_3 net_2 net_2 pmos
M7 out1firststage ibias source_nmos source_nmos nmos
M8 out2firststage ibias source_nmos source_nmos nmos
M9 net_1 ibias source_nmos source_nmos nmos
M10 net_6 out2 net_7 net_7 nmos
M11 outfeedback vref net_7 net_7 nmos
M12 net_6 out1 net_8 net_8 nmos
M13 outfeedback vref net_8 net_8 nmos
M14 net_6 net_6 source_pmos source_pmos pmos
M15 outfeedback outfeedback source_pmos source_pmos pmos
M16 net_7 ibias source_nmos source_nmos nmos
M17 net_8 ibias source_nmos source_nmos nmos
M18 out1 out1firststage source_pmos source_pmos pmos
M19 net_10 ibias source_nmos source_nmos nmos
M20 out1 bias_n_1 net_10 net_10 nmos
M21 out2 out2firststage source_pmos source_pmos pmos
M22 net_13 ibias source_nmos source_nmos nmos
M23 out2 bias_n_1 net_13 net_13 nmos
M24 bias_n_1 bias_n_1 source_nmos source_nmos nmos
M25 ibias ibias source_nmos source_nmos nmos
M26 bias_p_3 bias_p_3 source_pmos source_pmos pmos
M27 bias_p_4 bias_p_4 source_pmos source_pmos pmos
M28 bias_n_1 bias_p_4 source_pmos source_pmos pmos
M29 bias_p_3 ibias source_nmos source_nmos nmos
M30 bias_p_4 ibias source_nmos source_nmos nmos
Cap_load_1 out1 source_nmos
Cap_load_2 out2 source_nmos
Cap_compensation_1 out1firststage out1
Cap_compensation_2 out2firststage out2
.end two_stage_fully_differential_op_amp200
