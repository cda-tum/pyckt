.suckt  two_stage_fully_differential_op_amp538 ibias in1 in2 out source_nmos source_pmos
M1 net_0 in1 net_1 net_1 pmos
M2 net_2 in2 net_1 net_1 pmos
M3 out1firststage net_3 net_0 net_0 pmos
M4 out2firststage net_3 net_2 net_2 pmos
M5 net_4 outfeedback source_nmos source_nmos nmos
M6 out1firststage bias_n_1 net_4 net_4 nmos
M7 net_6 outfeedback source_nmos source_nmos nmos
M8 out2firststage bias_n_1 net_6 net_6 nmos
M9 net_7 bias_p_4 source_pmos source_pmos pmos
M10 net_1 bias_p_3 net_7 net_7 pmos
M11 net_10 out2 net_11 net_11 pmos
M12 outfeedback vref net_11 net_11 pmos
M13 net_10 out1 net_12 net_12 pmos
M14 outfeedback vref net_12 net_12 pmos
M15 net_10 net_10 source_nmos source_nmos nmos
M16 outfeedback outfeedback source_nmos source_nmos nmos
M17 net_11 bias_p_4 source_pmos source_pmos pmos
M18 net_12 bias_p_4 source_pmos source_pmos pmos
M19 net_14 out1firststage source_pmos source_pmos pmos
M20 out1 bias_p_3 net_14 net_14 pmos
M21 out1 ibias source_nmos source_nmos nmos
M22 net_17 out2firststage source_pmos source_pmos pmos
M23 out2 bias_p_3 net_17 net_17 pmos
M24 out2 ibias source_nmos source_nmos nmos
M25 bias_n_1 bias_n_1 source_nmos source_nmos nmos
M26 ibias ibias source_nmos source_nmos nmos
M27 net_3 net_3 net_1 net_1 pmos
M28 bias_p_3 bias_p_3 source_pmos source_pmos pmos
M29 bias_p_4 bias_p_4 source_pmos source_pmos pmos
M30 bias_p_4 ibias source_nmos source_nmos nmos
M31 bias_n_1 bias_p_4 source_pmos source_pmos pmos
M32 net_3 ibias source_nmos source_nmos nmos
M33 bias_p_3 ibias source_nmos source_nmos nmos
Cap_load_1 out1 source_nmos
Cap_load_2 out2 source_nmos
Cap_compensation_1 out1firststage out1
Cap_compensation_2 out2firststage out2
.end two_stage_fully_differential_op_amp538
