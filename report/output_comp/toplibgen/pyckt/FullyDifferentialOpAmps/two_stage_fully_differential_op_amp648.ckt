.suckt  two_stage_fully_differential_op_amp648 ibias in1 in2 out source_nmos source_pmos
M1 out1firststage in1 net_0 net_0 nmos
M2 out2firststage in2 net_0 net_0 nmos
M3 net_1 outfeedback source_pmos source_pmos pmos
M4 out1firststage bias_p_4 net_1 net_1 pmos
M5 net_3 outfeedback source_pmos source_pmos pmos
M6 out2firststage bias_p_4 net_3 net_3 pmos
M7 net_4 bias_n_3b source_nmos source_nmos nmos
M8 net_0 ibias net_4 net_4 nmos
M9 net_7 out2 net_8 net_8 nmos
M10 outfeedback vref net_8 net_8 nmos
M11 net_7 out1 net_9 net_9 nmos
M12 outfeedback vref net_9 net_9 nmos
M13 net_7 net_7 source_pmos source_pmos pmos
M14 outfeedback outfeedback source_pmos source_pmos pmos
M15 net_10 bias_n_3b source_nmos source_nmos nmos
M16 net_8 ibias net_10 net_10 nmos
M17 net_13 bias_n_3b source_nmos source_nmos nmos
M18 net_9 ibias net_13 net_13 nmos
M19 net_14 out1firststage source_pmos source_pmos pmos
M20 out1 bias_p_4 net_14 net_14 pmos
M21 net_16 net_16 source_nmos source_nmos nmos
M22 out1 net_17 net_16 net_16 nmos
M23 net_18 out2firststage source_pmos source_pmos pmos
M24 out2 bias_p_4 net_18 net_18 pmos
M25 net_20 net_20 source_nmos source_nmos nmos
M26 out2 net_21 net_20 net_20 nmos
M27 net_17 net_17 bias_n_1m bias_n_1m nmos
M28 bias_n_1m net_16 source_nmos source_nmos nmos
M29 net_21 net_21 bias_n_2m bias_n_2m nmos
M30 bias_n_2m net_20 source_nmos source_nmos nmos
M31 bias_n_3b bias_n_3b source_nmos source_nmos nmos
M32 ibias ibias bias_n_3b bias_n_3b nmos
M33 bias_p_4 bias_p_4 source_pmos source_pmos pmos
M34 bias_p_5 bias_p_5 source_pmos source_pmos pmos
M35 bias_p_4 bias_n_3b source_nmos source_nmos nmos
M36 net_17 bias_p_5 source_pmos source_pmos pmos
M37 net_21 bias_p_5 source_pmos source_pmos pmos
M38 bias_p_5 bias_n_3b source_nmos source_nmos nmos
Cap_load_1 out1 source_nmos
Cap_load_2 out2 source_nmos
Cap_compensation_1 out1firststage out1
Cap_compensation_2 out2firststage out2
.end two_stage_fully_differential_op_amp648
