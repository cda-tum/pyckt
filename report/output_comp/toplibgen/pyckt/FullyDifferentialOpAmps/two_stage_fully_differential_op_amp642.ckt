.suckt  two_stage_fully_differential_op_amp642 ibias in1 in2 out source_nmos source_pmos
M1 out1firststage in1 net_0 net_0 nmos
M2 out2firststage in2 net_0 net_0 nmos
M3 net_1 outfeedback source_pmos source_pmos pmos
M4 out1firststage bias_p_5 net_1 net_1 pmos
M5 net_3 outfeedback source_pmos source_pmos pmos
M6 out2firststage bias_p_5 net_3 net_3 pmos
M7 net_4 ibias source_nmos source_nmos nmos
M8 net_0 bias_n_1 net_4 net_4 nmos
M9 net_7 out2 net_8 net_8 nmos
M10 outfeedback vref net_8 net_8 nmos
M11 net_7 out1 net_9 net_9 nmos
M12 outfeedback vref net_9 net_9 nmos
M13 net_7 net_7 source_pmos source_pmos pmos
M14 outfeedback outfeedback source_pmos source_pmos pmos
M15 net_10 ibias source_nmos source_nmos nmos
M16 net_8 bias_n_1 net_10 net_10 nmos
M17 net_13 ibias source_nmos source_nmos nmos
M18 net_9 bias_n_1 net_13 net_13 nmos
M19 net_14 net_14 source_pmos source_pmos pmos
M20 out1 net_15 net_14 net_14 pmos
M21 net_16 out1firststage source_nmos source_nmos nmos
M22 out1 bias_n_1 net_16 net_16 nmos
M23 net_18 net_18 source_pmos source_pmos pmos
M24 out2 net_19 net_18 net_18 pmos
M25 net_20 out2firststage source_nmos source_nmos nmos
M26 out2 bias_n_1 net_20 net_20 nmos
M27 bias_n_1 bias_n_1 source_nmos source_nmos nmos
M28 ibias ibias source_nmos source_nmos nmos
M29 net_15 net_15 bias_p_3m bias_p_3m pmos
M30 bias_p_3m net_14 source_pmos source_pmos pmos
M31 net_19 net_19 bias_p_4m bias_p_4m pmos
M32 bias_p_4m net_18 source_pmos source_pmos pmos
M33 bias_p_5 bias_p_5 source_pmos source_pmos pmos
M34 bias_p_6 bias_p_6 source_pmos source_pmos pmos
M35 net_19 ibias source_nmos source_nmos nmos
M36 bias_n_1 bias_p_6 source_pmos source_pmos pmos
M37 bias_p_5 ibias source_nmos source_nmos nmos
M38 net_15 ibias source_nmos source_nmos nmos
M39 bias_p_6 ibias source_nmos source_nmos nmos
Cap_load_1 out1 source_nmos
Cap_load_2 out2 source_nmos
Cap_compensation_1 out1firststage out1
Cap_compensation_2 out2firststage out2
.end two_stage_fully_differential_op_amp642
