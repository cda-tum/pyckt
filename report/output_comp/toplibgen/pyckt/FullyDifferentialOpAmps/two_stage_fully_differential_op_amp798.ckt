.suckt  two_stage_fully_differential_op_amp798 ibias in1 in2 out source_nmos source_pmos
M1 net_0 in1 net_1 net_1 nmos
M2 net_2 in2 net_1 net_1 nmos
M3 out1firststage net_3 net_0 net_0 nmos
M4 out2firststage net_3 net_2 net_2 nmos
M5 out1firststage outfeedback source_pmos source_pmos pmos
M6 out2firststage outfeedback source_pmos source_pmos pmos
M7 net_4 net_4 source_nmos source_nmos nmos
M8 net_1 net_5 net_4 net_4 nmos
M9 net_6 out2 net_7 net_7 nmos
M10 outfeedback vref net_7 net_7 nmos
M11 net_6 out1 net_8 net_8 nmos
M12 outfeedback vref net_8 net_8 nmos
M13 net_6 net_6 source_pmos source_pmos pmos
M14 outfeedback outfeedback source_pmos source_pmos pmos
M15 net_7 bias_n_3 source_nmos source_nmos nmos
M16 net_8 bias_n_3 source_nmos source_nmos nmos
M17 net_10 net_10 source_pmos source_pmos pmos
M18 out1 net_11 net_10 net_10 pmos
M19 net_12 out1firststage source_nmos source_nmos nmos
M20 out1 bias_n_2 net_12 net_12 nmos
M21 net_14 net_14 source_pmos source_pmos pmos
M22 out2 ibias net_14 net_14 pmos
M23 net_16 out2firststage source_nmos source_nmos nmos
M24 out2 bias_n_2 net_16 net_16 nmos
M25 net_3 net_3 net_1 net_1 nmos
M26 net_5 net_5 bias_n_1m bias_n_1m nmos
M27 bias_n_1m net_4 source_nmos source_nmos nmos
M28 bias_n_2 bias_n_2 source_nmos source_nmos nmos
M29 bias_n_3 bias_n_3 source_nmos source_nmos nmos
M30 net_11 net_11 bias_p_4m bias_p_4m pmos
M31 bias_p_4m net_10 source_pmos source_pmos pmos
M32 ibias ibias bias_p_5m bias_p_5m pmos
M33 bias_p_5m net_14 source_pmos source_pmos pmos
M34 bias_n_3 net_14 source_pmos source_pmos pmos
M35 net_3 net_14 source_pmos source_pmos pmos
M36 bias_n_2 net_14 source_pmos source_pmos pmos
M37 net_5 net_14 source_pmos source_pmos pmos
M38 net_11 bias_n_3 source_nmos source_nmos nmos
Cap_load_1 out1 source_nmos
Cap_load_2 out2 source_nmos
Cap_compensation_1 out1firststage out1
Cap_compensation_2 out2firststage out2
.end two_stage_fully_differential_op_amp798
