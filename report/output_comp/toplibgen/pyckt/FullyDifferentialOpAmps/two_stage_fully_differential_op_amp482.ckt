.suckt  two_stage_fully_differential_op_amp482 ibias in1 in2 out source_nmos source_pmos
M1 net_0 in1 net_1 net_1 pmos
M2 net_2 in2 net_1 net_1 pmos
M3 out1firststage net_3 net_0 net_0 pmos
M4 out2firststage net_3 net_2 net_2 pmos
M5 out1firststage outfeedback source_nmos source_nmos nmos
M6 out2firststage outfeedback source_nmos source_nmos nmos
M7 net_4 ibias source_pmos source_pmos pmos
M8 net_1 bias_p_2 net_4 net_4 pmos
M9 net_7 out2 net_8 net_8 pmos
M10 outfeedback vref net_8 net_8 pmos
M11 net_7 out1 net_9 net_9 pmos
M12 outfeedback vref net_9 net_9 pmos
M13 net_7 net_7 source_nmos source_nmos nmos
M14 outfeedback outfeedback source_nmos source_nmos nmos
M15 net_8 ibias source_pmos source_pmos pmos
M16 net_9 ibias source_pmos source_pmos pmos
M17 out1 ibias source_pmos source_pmos pmos
M18 net_12 out1firststage source_nmos source_nmos nmos
M19 out1 bias_n_1 net_12 net_12 nmos
M20 out2 ibias source_pmos source_pmos pmos
M21 net_15 out2firststage source_nmos source_nmos nmos
M22 out2 bias_n_1 net_15 net_15 nmos
M23 bias_n_1 bias_n_1 source_nmos source_nmos nmos
M24 net_3 net_3 net_1 net_1 pmos
M25 bias_p_2 bias_p_2 source_pmos source_pmos pmos
M26 ibias ibias source_pmos source_pmos pmos
M27 bias_n_4 bias_n_4 source_nmos source_nmos nmos
M28 bias_n_1 ibias source_pmos source_pmos pmos
M29 net_3 bias_n_4 source_nmos source_nmos nmos
M30 bias_p_2 bias_n_4 source_nmos source_nmos nmos
M31 bias_n_4 ibias source_pmos source_pmos pmos
Cap_load_1 out1 source_nmos
Cap_load_2 out2 source_nmos
Cap_compensation_1 out1firststage out1
Cap_compensation_2 out2firststage out2
.end two_stage_fully_differential_op_amp482
