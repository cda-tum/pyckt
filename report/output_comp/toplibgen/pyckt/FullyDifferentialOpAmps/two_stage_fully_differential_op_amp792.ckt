.suckt  two_stage_fully_differential_op_amp792 ibias in1 in2 out source_nmos source_pmos
M1 net_0 in1 net_1 net_1 nmos
M2 net_2 in2 net_1 net_1 nmos
M3 out1firststage net_3 net_0 net_0 nmos
M4 out2firststage net_3 net_2 net_2 nmos
M5 out1firststage outfeedback source_pmos source_pmos pmos
M6 out2firststage outfeedback source_pmos source_pmos pmos
M7 net_4 bias_n_3b source_nmos source_nmos nmos
M8 net_1 ibias net_4 net_4 nmos
M9 net_7 out2 net_8 net_8 nmos
M10 outfeedback vref net_8 net_8 nmos
M11 net_7 out1 net_9 net_9 nmos
M12 outfeedback vref net_9 net_9 nmos
M13 net_7 net_7 source_pmos source_pmos pmos
M14 outfeedback outfeedback source_pmos source_pmos pmos
M15 net_10 bias_n_3b source_nmos source_nmos nmos
M16 net_8 ibias net_10 net_10 nmos
M17 net_13 bias_n_3b source_nmos source_nmos nmos
M18 net_9 ibias net_13 net_13 nmos
M19 net_14 out1firststage source_pmos source_pmos pmos
M20 out1 bias_p_4 net_14 net_14 pmos
M21 net_16 net_16 source_nmos source_nmos nmos
M22 out1 net_17 net_16 net_16 nmos
M23 net_18 out2firststage source_pmos source_pmos pmos
M24 out2 bias_p_4 net_18 net_18 pmos
M25 net_20 net_20 source_nmos source_nmos nmos
M26 out2 net_21 net_20 net_20 nmos
M27 net_3 net_3 net_1 net_1 nmos
M28 net_17 net_17 bias_n_1m bias_n_1m nmos
M29 bias_n_1m net_16 source_nmos source_nmos nmos
M30 net_21 net_21 bias_n_2m bias_n_2m nmos
M31 bias_n_2m net_20 source_nmos source_nmos nmos
M32 bias_n_3b bias_n_3b source_nmos source_nmos nmos
M33 ibias ibias bias_n_3b bias_n_3b nmos
M34 bias_p_4 bias_p_4 source_pmos source_pmos pmos
M35 bias_p_5 bias_p_5 source_pmos source_pmos pmos
M36 net_3 bias_p_5 source_pmos source_pmos pmos
M37 bias_p_4 bias_n_3b source_nmos source_nmos nmos
M38 net_17 bias_p_5 source_pmos source_pmos pmos
M39 net_21 bias_p_5 source_pmos source_pmos pmos
M40 bias_p_5 bias_n_3b source_nmos source_nmos nmos
Cap_load_1 out1 source_nmos
Cap_load_2 out2 source_nmos
Cap_compensation_1 out1firststage out1
Cap_compensation_2 out2firststage out2
.end two_stage_fully_differential_op_amp792
