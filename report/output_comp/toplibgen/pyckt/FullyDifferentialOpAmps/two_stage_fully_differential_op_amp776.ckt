.suckt  two_stage_fully_differential_op_amp776 ibias in1 in2 out source_nmos source_pmos
M1 net_0 in1 net_1 net_1 nmos
M2 net_2 in2 net_1 net_1 nmos
M3 out1firststage net_3 net_0 net_0 nmos
M4 out2firststage net_3 net_2 net_2 nmos
M5 out1firststage outfeedback source_pmos source_pmos pmos
M6 out2firststage outfeedback source_pmos source_pmos pmos
M7 net_4 ibias source_nmos source_nmos nmos
M8 net_1 bias_n_1 net_4 net_4 nmos
M9 net_7 out2 net_8 net_8 nmos
M10 outfeedback vref net_8 net_8 nmos
M11 net_7 out1 net_9 net_9 nmos
M12 outfeedback vref net_9 net_9 nmos
M13 net_7 net_7 source_pmos source_pmos pmos
M14 outfeedback outfeedback source_pmos source_pmos pmos
M15 net_8 ibias source_nmos source_nmos nmos
M16 net_9 ibias source_nmos source_nmos nmos
M17 out1 out1firststage source_pmos source_pmos pmos
M18 net_11 ibias source_nmos source_nmos nmos
M19 out1 bias_n_1 net_11 net_11 nmos
M20 out2 out2firststage source_pmos source_pmos pmos
M21 net_14 ibias source_nmos source_nmos nmos
M22 out2 bias_n_1 net_14 net_14 nmos
M23 net_3 net_3 net_1 net_1 nmos
M24 bias_n_1 bias_n_1 source_nmos source_nmos nmos
M25 ibias ibias source_nmos source_nmos nmos
M26 bias_p_3 bias_p_3 source_pmos source_pmos pmos
M27 net_3 bias_p_3 source_pmos source_pmos pmos
M28 bias_n_1 bias_p_3 source_pmos source_pmos pmos
M29 bias_p_3 ibias source_nmos source_nmos nmos
Cap_load_1 out1 source_nmos
Cap_load_2 out2 source_nmos
Cap_compensation_1 out1firststage out1
Cap_compensation_2 out2firststage out2
.end two_stage_fully_differential_op_amp776
