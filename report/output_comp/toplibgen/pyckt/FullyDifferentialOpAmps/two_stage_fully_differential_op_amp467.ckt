.suckt  two_stage_fully_differential_op_amp467 ibias in1 in2 out source_nmos source_pmos
M1 net_0 in1 net_1 net_1 pmos
M2 net_2 in2 net_1 net_1 pmos
M3 net_0 outfeedback source_nmos source_nmos nmos
M4 out1firststage bias_n_1 net_0 net_0 nmos
M5 net_2 outfeedback source_nmos source_nmos nmos
M6 out2firststage bias_n_1 net_2 net_2 nmos
M7 net_4 bias_p_5 source_pmos source_pmos pmos
M8 out1firststage bias_p_4 net_4 net_4 pmos
M9 net_7 bias_p_5 source_pmos source_pmos pmos
M10 out2firststage bias_p_4 net_7 net_7 pmos
M11 net_8 net_8 source_pmos source_pmos pmos
M12 net_1 net_9 net_8 net_8 pmos
M13 net_10 out2 net_11 net_11 pmos
M14 outfeedback vref net_11 net_11 pmos
M15 net_10 out1 net_12 net_12 pmos
M16 outfeedback vref net_12 net_12 pmos
M17 net_10 net_10 source_nmos source_nmos nmos
M18 outfeedback outfeedback source_nmos source_nmos nmos
M19 net_11 bias_p_5 source_pmos source_pmos pmos
M20 net_12 bias_p_5 source_pmos source_pmos pmos
M21 net_14 out1firststage source_pmos source_pmos pmos
M22 out1 bias_p_4 net_14 net_14 pmos
M23 net_16 ibias source_nmos source_nmos nmos
M24 out1 bias_n_1 net_16 net_16 nmos
M25 net_19 out2firststage source_pmos source_pmos pmos
M26 out2 bias_p_4 net_19 net_19 pmos
M27 net_21 ibias source_nmos source_nmos nmos
M28 out2 bias_n_1 net_21 net_21 nmos
M29 bias_n_1 bias_n_1 source_nmos source_nmos nmos
M30 ibias ibias source_nmos source_nmos nmos
M31 net_9 net_9 bias_p_3m bias_p_3m pmos
M32 bias_p_3m net_8 source_pmos source_pmos pmos
M33 bias_p_4 bias_p_4 source_pmos source_pmos pmos
M34 bias_p_5 bias_p_5 source_pmos source_pmos pmos
M35 bias_p_5 ibias source_nmos source_nmos nmos
M36 bias_n_1 bias_p_5 source_pmos source_pmos pmos
M37 bias_p_4 ibias source_nmos source_nmos nmos
M38 net_9 ibias source_nmos source_nmos nmos
Cap_load_1 out1 source_nmos
Cap_load_2 out2 source_nmos
Cap_compensation_1 out1firststage out1
Cap_compensation_2 out2firststage out2
.end two_stage_fully_differential_op_amp467
