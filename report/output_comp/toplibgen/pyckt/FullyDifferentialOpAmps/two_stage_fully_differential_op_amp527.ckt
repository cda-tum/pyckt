.suckt  two_stage_fully_differential_op_amp527 ibias in1 in2 out source_nmos source_pmos
M1 net_0 in1 net_1 net_1 pmos
M2 net_2 in2 net_1 net_1 pmos
M3 out1firststage net_3 net_0 net_0 pmos
M4 out2firststage net_3 net_2 net_2 pmos
M5 out1firststage outfeedback source_nmos source_nmos nmos
M6 out2firststage outfeedback source_nmos source_nmos nmos
M7 net_4 net_4 source_pmos source_pmos pmos
M8 net_1 net_5 net_4 net_4 pmos
M9 net_6 out2 net_7 net_7 pmos
M10 outfeedback vref net_7 net_7 pmos
M11 net_6 out1 net_8 net_8 pmos
M12 outfeedback vref net_8 net_8 pmos
M13 net_6 net_6 source_nmos source_nmos nmos
M14 outfeedback outfeedback source_nmos source_nmos nmos
M15 net_9 bias_p_4 source_pmos source_pmos pmos
M16 net_7 bias_p_3 net_9 net_9 pmos
M17 net_12 bias_p_4 source_pmos source_pmos pmos
M18 net_8 bias_p_3 net_12 net_12 pmos
M19 net_13 out1firststage source_pmos source_pmos pmos
M20 out1 bias_p_3 net_13 net_13 pmos
M21 net_15 bias_n_1b source_nmos source_nmos nmos
M22 out1 ibias net_15 net_15 nmos
M23 net_18 out2firststage source_pmos source_pmos pmos
M24 out2 bias_p_3 net_18 net_18 pmos
M25 net_20 bias_n_1b source_nmos source_nmos nmos
M26 out2 ibias net_20 net_20 nmos
M27 bias_n_1b bias_n_1b source_nmos source_nmos nmos
M28 ibias ibias bias_n_1b bias_n_1b nmos
M29 net_3 net_3 net_1 net_1 pmos
M30 net_5 net_5 bias_p_2m bias_p_2m pmos
M31 bias_p_2m net_4 source_pmos source_pmos pmos
M32 bias_p_3 bias_p_3 source_pmos source_pmos pmos
M33 bias_p_4 bias_p_4 source_pmos source_pmos pmos
M34 bias_p_4 bias_n_1b source_nmos source_nmos nmos
M35 net_3 bias_n_1b source_nmos source_nmos nmos
M36 bias_p_3 bias_n_1b source_nmos source_nmos nmos
M37 net_5 bias_n_1b source_nmos source_nmos nmos
Cap_load_1 out1 source_nmos
Cap_load_2 out2 source_nmos
Cap_compensation_1 out1firststage out1
Cap_compensation_2 out2firststage out2
.end two_stage_fully_differential_op_amp527
