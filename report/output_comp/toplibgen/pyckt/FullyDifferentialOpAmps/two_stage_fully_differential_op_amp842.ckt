.suckt  two_stage_fully_differential_op_amp842 ibias in1 in2 out source_nmos source_pmos
M1 net_0 in1 net_1 net_1 nmos
M2 net_2 in2 net_1 net_1 nmos
M3 out1firststage net_3 net_0 net_0 nmos
M4 out2firststage net_3 net_2 net_2 nmos
M5 net_4 outfeedback source_pmos source_pmos pmos
M6 out1firststage bias_p_4 net_4 net_4 pmos
M7 net_6 outfeedback source_pmos source_pmos pmos
M8 out2firststage bias_p_4 net_6 net_6 pmos
M9 net_7 net_7 source_nmos source_nmos nmos
M10 net_1 net_8 net_7 net_7 nmos
M11 net_9 out2 net_10 net_10 nmos
M12 outfeedback vref net_10 net_10 nmos
M13 net_9 out1 net_11 net_11 nmos
M14 outfeedback vref net_11 net_11 nmos
M15 net_9 net_9 source_pmos source_pmos pmos
M16 outfeedback outfeedback source_pmos source_pmos pmos
M17 net_10 bias_n_3 source_nmos source_nmos nmos
M18 net_11 bias_n_3 source_nmos source_nmos nmos
M19 out1 ibias source_pmos source_pmos pmos
M20 net_14 out1firststage source_nmos source_nmos nmos
M21 out1 bias_n_2 net_14 net_14 nmos
M22 out2 ibias source_pmos source_pmos pmos
M23 net_17 out2firststage source_nmos source_nmos nmos
M24 out2 bias_n_2 net_17 net_17 nmos
M25 net_3 net_3 net_1 net_1 nmos
M26 net_8 net_8 bias_n_1m bias_n_1m nmos
M27 bias_n_1m net_7 source_nmos source_nmos nmos
M28 bias_n_2 bias_n_2 source_nmos source_nmos nmos
M29 bias_n_3 bias_n_3 source_nmos source_nmos nmos
M30 bias_p_4 bias_p_4 source_pmos source_pmos pmos
M31 ibias ibias source_pmos source_pmos pmos
M32 bias_n_3 ibias source_pmos source_pmos pmos
M33 net_3 ibias source_pmos source_pmos pmos
M34 bias_n_2 ibias source_pmos source_pmos pmos
M35 bias_p_4 bias_n_3 source_nmos source_nmos nmos
M36 net_8 ibias source_pmos source_pmos pmos
Cap_load_1 out1 source_nmos
Cap_load_2 out2 source_nmos
Cap_compensation_1 out1firststage out1
Cap_compensation_2 out2firststage out2
.end two_stage_fully_differential_op_amp842
