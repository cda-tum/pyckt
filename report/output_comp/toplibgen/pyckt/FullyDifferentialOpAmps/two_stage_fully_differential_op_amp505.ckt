.suckt  two_stage_fully_differential_op_amp505 ibias in1 in2 out source_nmos source_pmos
M1 net_0 in1 net_1 net_1 pmos
M2 net_2 in2 net_1 net_1 pmos
M3 out1firststage net_3 net_0 net_0 pmos
M4 out2firststage net_3 net_2 net_2 pmos
M5 out1firststage outfeedback source_nmos source_nmos nmos
M6 out2firststage outfeedback source_nmos source_nmos nmos
M7 net_4 net_4 source_pmos source_pmos pmos
M8 net_1 net_5 net_4 net_4 pmos
M9 net_6 out2 net_7 net_7 pmos
M10 outfeedback vref net_7 net_7 pmos
M11 net_6 out1 net_8 net_8 pmos
M12 outfeedback vref net_8 net_8 pmos
M13 net_6 net_6 source_nmos source_nmos nmos
M14 outfeedback outfeedback source_nmos source_nmos nmos
M15 net_7 ibias source_pmos source_pmos pmos
M16 net_8 ibias source_pmos source_pmos pmos
M17 out1 ibias source_pmos source_pmos pmos
M18 out1 out1firststage source_nmos source_nmos nmos
M19 out2 ibias source_pmos source_pmos pmos
M20 out2 out2firststage source_nmos source_nmos nmos
M21 net_3 net_3 net_1 net_1 pmos
M22 net_5 net_5 bias_p_1m bias_p_1m pmos
M23 bias_p_1m net_4 source_pmos source_pmos pmos
M24 ibias ibias source_pmos source_pmos pmos
M25 bias_n_3 bias_n_3 source_nmos source_nmos nmos
M26 net_3 bias_n_3 source_nmos source_nmos nmos
M27 net_5 bias_n_3 source_nmos source_nmos nmos
M28 bias_n_3 ibias source_pmos source_pmos pmos
Cap_load_1 out1 source_nmos
Cap_load_2 out2 source_nmos
Cap_compensation_1 out1firststage out1
Cap_compensation_2 out2firststage out2
.end two_stage_fully_differential_op_amp505
