.suckt  two_stage_fully_differential_op_amp768 ibias in1 in2 out source_nmos source_pmos
M1 net_0 in1 net_1 net_1 nmos
M2 net_2 in2 net_1 net_1 nmos
M3 net_0 outfeedback source_pmos source_pmos pmos
M4 out1firststage bias_p_5 net_0 net_0 pmos
M5 net_2 outfeedback source_pmos source_pmos pmos
M6 out2firststage bias_p_5 net_2 net_2 pmos
M7 net_4 bias_n_4b source_nmos source_nmos nmos
M8 out1firststage ibias net_4 net_4 nmos
M9 net_7 bias_n_4b source_nmos source_nmos nmos
M10 out2firststage ibias net_7 net_7 nmos
M11 net_8 net_8 source_nmos source_nmos nmos
M12 net_1 net_9 net_8 net_8 nmos
M13 net_10 out2 net_11 net_11 nmos
M14 outfeedback vref net_11 net_11 nmos
M15 net_10 out1 net_12 net_12 nmos
M16 outfeedback vref net_12 net_12 nmos
M17 net_10 net_10 source_pmos source_pmos pmos
M18 outfeedback outfeedback source_pmos source_pmos pmos
M19 net_13 bias_n_4b source_nmos source_nmos nmos
M20 net_11 ibias net_13 net_13 nmos
M21 net_16 bias_n_4b source_nmos source_nmos nmos
M22 net_12 ibias net_16 net_16 nmos
M23 net_17 out1firststage source_pmos source_pmos pmos
M24 out1 bias_p_5 net_17 net_17 pmos
M25 net_19 net_19 source_nmos source_nmos nmos
M26 out1 net_20 net_19 net_19 nmos
M27 net_21 out2firststage source_pmos source_pmos pmos
M28 out2 bias_p_5 net_21 net_21 pmos
M29 net_23 net_23 source_nmos source_nmos nmos
M30 out2 net_24 net_23 net_23 nmos
M31 net_9 net_9 bias_n_1m bias_n_1m nmos
M32 bias_n_1m net_8 source_nmos source_nmos nmos
M33 net_20 net_20 bias_n_2m bias_n_2m nmos
M34 bias_n_2m net_19 source_nmos source_nmos nmos
M35 net_24 net_24 bias_n_3m bias_n_3m nmos
M36 bias_n_3m net_23 source_nmos source_nmos nmos
M37 bias_n_4b bias_n_4b source_nmos source_nmos nmos
M38 ibias ibias bias_n_4b bias_n_4b nmos
M39 bias_p_5 bias_p_5 source_pmos source_pmos pmos
M40 bias_p_6 bias_p_6 source_pmos source_pmos pmos
M41 bias_p_5 bias_n_4b source_nmos source_nmos nmos
M42 net_9 bias_p_6 source_pmos source_pmos pmos
M43 net_20 bias_p_6 source_pmos source_pmos pmos
M44 net_24 bias_p_6 source_pmos source_pmos pmos
M45 bias_p_6 bias_n_4b source_nmos source_nmos nmos
Cap_load_1 out1 source_nmos
Cap_load_2 out2 source_nmos
Cap_compensation_1 out1firststage out1
Cap_compensation_2 out2firststage out2
.end two_stage_fully_differential_op_amp768
