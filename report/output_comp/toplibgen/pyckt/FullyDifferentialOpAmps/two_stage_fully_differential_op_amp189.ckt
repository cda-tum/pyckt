.suckt  two_stage_fully_differential_op_amp189 ibias in1 in2 out source_nmos source_pmos
M1 out1firststage in1 net_0 net_0 nmos
M2 out2firststage in2 net_0 net_0 nmos
M3 net_1 outfeedback source_pmos source_pmos pmos
M4 out1firststage bias_p_5 net_1 net_1 pmos
M5 net_3 outfeedback source_pmos source_pmos pmos
M6 out2firststage bias_p_5 net_3 net_3 pmos
M7 net_0 ibias source_nmos source_nmos nmos
M8 net_5 out2 net_6 net_6 nmos
M9 outfeedback vref net_6 net_6 nmos
M10 net_5 out1 net_7 net_7 nmos
M11 outfeedback vref net_7 net_7 nmos
M12 net_5 net_5 source_pmos source_pmos pmos
M13 outfeedback outfeedback source_pmos source_pmos pmos
M14 net_8 ibias source_nmos source_nmos nmos
M15 net_6 bias_n_3 net_8 net_8 nmos
M16 net_11 ibias source_nmos source_nmos nmos
M17 net_7 bias_n_3 net_11 net_11 nmos
M18 out1 out1firststage source_pmos source_pmos pmos
M19 net_12 net_12 source_nmos source_nmos nmos
M20 out1 net_13 net_12 net_12 nmos
M21 out2 out2firststage source_pmos source_pmos pmos
M22 net_14 net_14 source_nmos source_nmos nmos
M23 out2 net_15 net_14 net_14 nmos
M24 net_13 net_13 bias_n_1m bias_n_1m nmos
M25 bias_n_1m net_12 source_nmos source_nmos nmos
M26 net_15 net_15 bias_n_2m bias_n_2m nmos
M27 bias_n_2m net_14 source_nmos source_nmos nmos
M28 bias_n_3 bias_n_3 source_nmos source_nmos nmos
M29 ibias ibias source_nmos source_nmos nmos
M30 bias_p_5 bias_p_5 source_pmos source_pmos pmos
M31 bias_p_6 bias_p_6 source_pmos source_pmos pmos
M32 bias_n_3 bias_p_6 source_pmos source_pmos pmos
M33 bias_p_5 ibias source_nmos source_nmos nmos
M34 net_13 bias_p_6 source_pmos source_pmos pmos
M35 net_15 bias_p_6 source_pmos source_pmos pmos
M36 bias_p_6 ibias source_nmos source_nmos nmos
Cap_load_1 out1 source_nmos
Cap_load_2 out2 source_nmos
Cap_compensation_1 out1firststage out1
Cap_compensation_2 out2firststage out2
.end two_stage_fully_differential_op_amp189
