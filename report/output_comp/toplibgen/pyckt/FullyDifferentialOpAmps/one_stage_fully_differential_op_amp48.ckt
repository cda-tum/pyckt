.suckt  one_stage_fully_differential_op_amp48 ibias in1 in2 out source_nmos source_pmos
M1 net_0 in1 net_1 net_1 pmos
M2 net_2 in2 net_1 net_1 pmos
M3 out1 net_3 net_0 net_0 pmos
M4 out2 net_3 net_2 net_2 pmos
M5 net_4 outfeedback source_nmos source_nmos nmos
M6 out1 bias_n_1 net_4 net_4 nmos
M7 net_6 outfeedback source_nmos source_nmos nmos
M8 out2 bias_n_1 net_6 net_6 nmos
M9 net_7 net_7 source_pmos source_pmos pmos
M10 net_1 net_8 net_7 net_7 pmos
M11 net_9 out2 net_10 net_10 pmos
M12 outfeedback vref net_10 net_10 pmos
M13 net_9 out1 net_11 net_11 pmos
M14 outfeedback vref net_11 net_11 pmos
M15 net_9 net_9 source_nmos source_nmos nmos
M16 outfeedback outfeedback source_nmos source_nmos nmos
M17 net_12 bias_p_3b source_pmos source_pmos pmos
M18 net_10 ibias net_12 net_12 pmos
M19 net_15 bias_p_3b source_pmos source_pmos pmos
M20 net_11 ibias net_15 net_15 pmos
M21 bias_n_1 bias_n_1 source_nmos source_nmos nmos
M22 net_3 net_3 net_1 net_1 pmos
M23 net_8 net_8 bias_p_2m bias_p_2m pmos
M24 bias_p_2m net_7 source_pmos source_pmos pmos
M25 bias_p_3b bias_p_3b source_pmos source_pmos pmos
M26 ibias ibias bias_p_3b bias_p_3b pmos
M27 bias_n_4 bias_n_4 source_nmos source_nmos nmos
M28 bias_n_1 bias_p_3b source_pmos source_pmos pmos
M29 net_3 bias_n_4 source_nmos source_nmos nmos
M30 net_8 bias_n_4 source_nmos source_nmos nmos
M31 bias_n_4 bias_p_3b source_pmos source_pmos pmos
Cap_load_1 out1 source_nmos
Cap_load_2 out2 source_nmos
.end one_stage_fully_differential_op_amp48
