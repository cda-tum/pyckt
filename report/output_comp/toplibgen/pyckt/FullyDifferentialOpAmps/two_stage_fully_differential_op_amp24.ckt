.suckt  two_stage_fully_differential_op_amp24 ibias in1 in2 out source_nmos source_pmos
M1 out1firststage in1 net_0 net_0 pmos
M2 out2firststage in2 net_0 net_0 pmos
M3 out1firststage outfeedback source_nmos source_nmos nmos
M4 out2firststage outfeedback source_nmos source_nmos nmos
M5 net_0 ibias source_pmos source_pmos pmos
M6 net_2 out2 net_3 net_3 pmos
M7 outfeedback vref net_3 net_3 pmos
M8 net_2 out1 net_4 net_4 pmos
M9 outfeedback vref net_4 net_4 pmos
M10 net_2 net_2 source_nmos source_nmos nmos
M11 outfeedback outfeedback source_nmos source_nmos nmos
M12 net_5 ibias source_pmos source_pmos pmos
M13 net_3 bias_p_3 net_5 net_5 pmos
M14 net_8 ibias source_pmos source_pmos pmos
M15 net_4 bias_p_3 net_8 net_8 pmos
M16 net_9 out1firststage source_pmos source_pmos pmos
M17 out1 bias_p_3 net_9 net_9 pmos
M18 net_11 net_11 source_nmos source_nmos nmos
M19 out1 net_12 net_11 net_11 nmos
M20 net_13 out2firststage source_pmos source_pmos pmos
M21 out2 bias_p_3 net_13 net_13 pmos
M22 net_15 net_15 source_nmos source_nmos nmos
M23 out2 net_16 net_15 net_15 nmos
M24 net_12 net_12 bias_n_1m bias_n_1m nmos
M25 bias_n_1m net_11 source_nmos source_nmos nmos
M26 net_16 net_16 bias_n_2m bias_n_2m nmos
M27 bias_n_2m net_15 source_nmos source_nmos nmos
M28 bias_p_3 bias_p_3 source_pmos source_pmos pmos
M29 ibias ibias source_pmos source_pmos pmos
M30 bias_n_5 bias_n_5 source_nmos source_nmos nmos
M31 net_16 ibias source_pmos source_pmos pmos
M32 bias_p_3 bias_n_5 source_nmos source_nmos nmos
M33 net_12 ibias source_pmos source_pmos pmos
M34 bias_n_5 ibias source_pmos source_pmos pmos
Cap_load_1 out1 source_nmos
Cap_load_2 out2 source_nmos
Cap_compensation_1 out1firststage out1
Cap_compensation_2 out2firststage out2
.end two_stage_fully_differential_op_amp24
