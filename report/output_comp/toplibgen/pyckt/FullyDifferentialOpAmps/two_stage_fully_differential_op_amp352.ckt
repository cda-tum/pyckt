.suckt  two_stage_fully_differential_op_amp352 ibias in1 in2 out source_nmos source_pmos
M1 out1firststage in1 net_0 net_0 pmos
M2 out2firststage in2 net_0 net_0 pmos
M3 net_1 outfeedback source_nmos source_nmos nmos
M4 out1firststage bias_n_1 net_1 net_1 nmos
M5 net_3 outfeedback source_nmos source_nmos nmos
M6 out2firststage bias_n_1 net_3 net_3 nmos
M7 net_4 bias_p_2b source_pmos source_pmos pmos
M8 net_0 ibias net_4 net_4 pmos
M9 net_7 out2 net_8 net_8 pmos
M10 outfeedback vref net_8 net_8 pmos
M11 net_7 out1 net_9 net_9 pmos
M12 outfeedback vref net_9 net_9 pmos
M13 net_7 net_7 source_nmos source_nmos nmos
M14 outfeedback outfeedback source_nmos source_nmos nmos
M15 net_10 bias_p_2b source_pmos source_pmos pmos
M16 net_8 ibias net_10 net_10 pmos
M17 net_13 bias_p_2b source_pmos source_pmos pmos
M18 net_9 ibias net_13 net_13 pmos
M19 net_14 bias_p_2b source_pmos source_pmos pmos
M20 out1 ibias net_14 net_14 pmos
M21 net_17 out1firststage source_nmos source_nmos nmos
M22 out1 bias_n_1 net_17 net_17 nmos
M23 net_19 bias_p_2b source_pmos source_pmos pmos
M24 out2 ibias net_19 net_19 pmos
M25 net_22 out2firststage source_nmos source_nmos nmos
M26 out2 bias_n_1 net_22 net_22 nmos
M27 bias_n_1 bias_n_1 source_nmos source_nmos nmos
M28 bias_p_2b bias_p_2b source_pmos source_pmos pmos
M29 ibias ibias bias_p_2b bias_p_2b pmos
M30 bias_n_1 bias_p_2b source_pmos source_pmos pmos
Cap_load_1 out1 source_nmos
Cap_load_2 out2 source_nmos
Cap_compensation_1 out1firststage out1
Cap_compensation_2 out2firststage out2
.end two_stage_fully_differential_op_amp352
