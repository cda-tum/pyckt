.suckt  two_stage_fully_differential_op_amp711 ibias in1 in2 out source_nmos source_pmos
M1 net_0 in1 net_1 net_1 nmos
M2 net_2 in2 net_1 net_1 nmos
M3 net_0 outfeedback source_pmos source_pmos pmos
M4 out1firststage bias_p_4 net_0 net_0 pmos
M5 net_2 outfeedback source_pmos source_pmos pmos
M6 out2firststage bias_p_4 net_2 net_2 pmos
M7 out1firststage bias_n_3 source_nmos source_nmos nmos
M8 out2firststage bias_n_3 source_nmos source_nmos nmos
M9 net_5 net_5 source_nmos source_nmos nmos
M10 net_1 net_6 net_5 net_5 nmos
M11 net_7 out2 net_8 net_8 nmos
M12 outfeedback vref net_8 net_8 nmos
M13 net_7 out1 net_9 net_9 nmos
M14 outfeedback vref net_9 net_9 nmos
M15 net_7 net_7 source_pmos source_pmos pmos
M16 outfeedback outfeedback source_pmos source_pmos pmos
M17 net_10 bias_n_3 source_nmos source_nmos nmos
M18 net_8 bias_n_2 net_10 net_10 nmos
M19 net_13 bias_n_3 source_nmos source_nmos nmos
M20 net_9 bias_n_2 net_13 net_13 nmos
M21 net_14 ibias source_pmos source_pmos pmos
M22 out1 bias_p_4 net_14 net_14 pmos
M23 out1 out1firststage source_nmos source_nmos nmos
M24 net_17 ibias source_pmos source_pmos pmos
M25 out2 bias_p_4 net_17 net_17 pmos
M26 out2 out2firststage source_nmos source_nmos nmos
M27 net_6 net_6 bias_n_1m bias_n_1m nmos
M28 bias_n_1m net_5 source_nmos source_nmos nmos
M29 bias_n_2 bias_n_2 source_nmos source_nmos nmos
M30 bias_n_3 bias_n_3 source_nmos source_nmos nmos
M31 bias_p_4 bias_p_4 source_pmos source_pmos pmos
M32 ibias ibias source_pmos source_pmos pmos
M33 bias_n_3 ibias source_pmos source_pmos pmos
M34 bias_n_2 ibias source_pmos source_pmos pmos
M35 bias_p_4 bias_n_3 source_nmos source_nmos nmos
M36 net_6 ibias source_pmos source_pmos pmos
Cap_load_1 out1 source_nmos
Cap_load_2 out2 source_nmos
Cap_compensation_1 out1firststage out1
Cap_compensation_2 out2firststage out2
.end two_stage_fully_differential_op_amp711
