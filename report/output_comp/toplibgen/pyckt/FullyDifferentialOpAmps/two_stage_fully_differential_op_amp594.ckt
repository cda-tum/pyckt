.suckt  two_stage_fully_differential_op_amp594 ibias in1 in2 out source_nmos source_pmos
M1 out1firststage in1 net_0 net_0 nmos
M2 out2firststage in2 net_0 net_0 nmos
M3 out1firststage outfeedback source_pmos source_pmos pmos
M4 out2firststage outfeedback source_pmos source_pmos pmos
M5 net_1 ibias source_nmos source_nmos nmos
M6 net_0 bias_n_1 net_1 net_1 nmos
M7 net_4 out2 net_5 net_5 nmos
M8 outfeedback vref net_5 net_5 nmos
M9 net_4 out1 net_6 net_6 nmos
M10 outfeedback vref net_6 net_6 nmos
M11 net_4 net_4 source_pmos source_pmos pmos
M12 outfeedback outfeedback source_pmos source_pmos pmos
M13 net_7 ibias source_nmos source_nmos nmos
M14 net_5 bias_n_1 net_7 net_7 nmos
M15 net_10 ibias source_nmos source_nmos nmos
M16 net_6 bias_n_1 net_10 net_10 nmos
M17 net_11 net_11 source_pmos source_pmos pmos
M18 out1 net_12 net_11 net_11 pmos
M19 net_13 out1firststage source_nmos source_nmos nmos
M20 out1 bias_n_1 net_13 net_13 nmos
M21 net_15 net_15 source_pmos source_pmos pmos
M22 out2 net_16 net_15 net_15 pmos
M23 net_17 out2firststage source_nmos source_nmos nmos
M24 out2 bias_n_1 net_17 net_17 nmos
M25 bias_n_1 bias_n_1 source_nmos source_nmos nmos
M26 ibias ibias source_nmos source_nmos nmos
M27 net_12 net_12 bias_p_3m bias_p_3m pmos
M28 bias_p_3m net_11 source_pmos source_pmos pmos
M29 net_16 net_16 bias_p_4m bias_p_4m pmos
M30 bias_p_4m net_15 source_pmos source_pmos pmos
M31 bias_p_5 bias_p_5 source_pmos source_pmos pmos
M32 net_16 ibias source_nmos source_nmos nmos
M33 bias_n_1 bias_p_5 source_pmos source_pmos pmos
M34 net_12 ibias source_nmos source_nmos nmos
M35 bias_p_5 ibias source_nmos source_nmos nmos
Cap_load_1 out1 source_nmos
Cap_load_2 out2 source_nmos
Cap_compensation_1 out1firststage out1
Cap_compensation_2 out2firststage out2
.end two_stage_fully_differential_op_amp594
