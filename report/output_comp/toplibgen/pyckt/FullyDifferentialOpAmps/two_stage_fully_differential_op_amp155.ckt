.suckt  two_stage_fully_differential_op_amp155 ibias in1 in2 out source_nmos source_pmos
M1 out1firststage in1 net_0 net_0 nmos
M2 out2firststage in2 net_0 net_0 nmos
M3 out1firststage outfeedback source_pmos source_pmos pmos
M4 out2firststage outfeedback source_pmos source_pmos pmos
M5 net_0 ibias source_nmos source_nmos nmos
M6 net_2 out2 net_3 net_3 nmos
M7 outfeedback vref net_3 net_3 nmos
M8 net_2 out1 net_4 net_4 nmos
M9 outfeedback vref net_4 net_4 nmos
M10 net_2 net_2 source_pmos source_pmos pmos
M11 outfeedback outfeedback source_pmos source_pmos pmos
M12 net_3 ibias source_nmos source_nmos nmos
M13 net_4 ibias source_nmos source_nmos nmos
M14 net_6 out1firststage source_pmos source_pmos pmos
M15 out1 bias_p_3 net_6 net_6 pmos
M16 net_8 ibias source_nmos source_nmos nmos
M17 out1 bias_n_1 net_8 net_8 nmos
M18 net_11 out2firststage source_pmos source_pmos pmos
M19 out2 bias_p_3 net_11 net_11 pmos
M20 net_13 ibias source_nmos source_nmos nmos
M21 out2 bias_n_1 net_13 net_13 nmos
M22 bias_n_1 bias_n_1 source_nmos source_nmos nmos
M23 ibias ibias source_nmos source_nmos nmos
M24 bias_p_3 bias_p_3 source_pmos source_pmos pmos
M25 bias_p_4 bias_p_4 source_pmos source_pmos pmos
M26 bias_n_1 bias_p_4 source_pmos source_pmos pmos
M27 bias_p_3 ibias source_nmos source_nmos nmos
M28 bias_p_4 ibias source_nmos source_nmos nmos
Cap_load_1 out1 source_nmos
Cap_load_2 out2 source_nmos
Cap_compensation_1 out1firststage out1
Cap_compensation_2 out2firststage out2
.end two_stage_fully_differential_op_amp155
