.suckt  two_stage_fully_differential_op_amp799 ibias in1 in2 out source_nmos source_pmos
M1 net_0 in1 net_1 net_1 nmos
M2 net_2 in2 net_1 net_1 nmos
M3 out1firststage net_3 net_0 net_0 nmos
M4 out2firststage net_3 net_2 net_2 nmos
M5 out1firststage outfeedback source_pmos source_pmos pmos
M6 out2firststage outfeedback source_pmos source_pmos pmos
M7 net_4 net_4 source_nmos source_nmos nmos
M8 net_1 net_5 net_4 net_4 nmos
M9 net_6 out2 net_7 net_7 nmos
M10 outfeedback vref net_7 net_7 nmos
M11 net_6 out1 net_8 net_8 nmos
M12 outfeedback vref net_8 net_8 nmos
M13 net_6 net_6 source_pmos source_pmos pmos
M14 outfeedback outfeedback source_pmos source_pmos pmos
M15 net_7 ibias source_nmos source_nmos nmos
M16 net_8 ibias source_nmos source_nmos nmos
M17 out1 out1firststage source_pmos source_pmos pmos
M18 out1 ibias source_nmos source_nmos nmos
M19 out2 out2firststage source_pmos source_pmos pmos
M20 out2 ibias source_nmos source_nmos nmos
M21 net_3 net_3 net_1 net_1 nmos
M22 net_5 net_5 bias_n_1m bias_n_1m nmos
M23 bias_n_1m net_4 source_nmos source_nmos nmos
M24 ibias ibias source_nmos source_nmos nmos
M25 bias_p_3 bias_p_3 source_pmos source_pmos pmos
M26 net_3 bias_p_3 source_pmos source_pmos pmos
M27 net_5 bias_p_3 source_pmos source_pmos pmos
M28 bias_p_3 ibias source_nmos source_nmos nmos
Cap_load_1 out1 source_nmos
Cap_load_2 out2 source_nmos
Cap_compensation_1 out1firststage out1
Cap_compensation_2 out2firststage out2
.end two_stage_fully_differential_op_amp799
