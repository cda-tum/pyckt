.suckt  two_stage_fully_differential_op_amp503 ibias in1 in2 out source_nmos source_pmos
M1 net_0 in1 net_1 net_1 pmos
M2 net_2 in2 net_1 net_1 pmos
M3 out1firststage net_3 net_0 net_0 pmos
M4 out2firststage net_3 net_2 net_2 pmos
M5 out1firststage outfeedback source_nmos source_nmos nmos
M6 out2firststage outfeedback source_nmos source_nmos nmos
M7 net_4 bias_p_3 source_pmos source_pmos pmos
M8 net_1 bias_p_2 net_4 net_4 pmos
M9 net_7 out2 net_8 net_8 pmos
M10 outfeedback vref net_8 net_8 pmos
M11 net_7 out1 net_9 net_9 pmos
M12 outfeedback vref net_9 net_9 pmos
M13 net_7 net_7 source_nmos source_nmos nmos
M14 outfeedback outfeedback source_nmos source_nmos nmos
M15 net_10 bias_p_3 source_pmos source_pmos pmos
M16 net_8 bias_p_2 net_10 net_10 pmos
M17 net_13 bias_p_3 source_pmos source_pmos pmos
M18 net_9 bias_p_2 net_13 net_13 pmos
M19 net_14 out1firststage source_pmos source_pmos pmos
M20 out1 bias_p_2 net_14 net_14 pmos
M21 net_16 bias_n_1b source_nmos source_nmos nmos
M22 out1 ibias net_16 net_16 nmos
M23 net_19 out2firststage source_pmos source_pmos pmos
M24 out2 bias_p_2 net_19 net_19 pmos
M25 net_21 bias_n_1b source_nmos source_nmos nmos
M26 out2 ibias net_21 net_21 nmos
M27 bias_n_1b bias_n_1b source_nmos source_nmos nmos
M28 ibias ibias bias_n_1b bias_n_1b nmos
M29 net_3 net_3 net_1 net_1 pmos
M30 bias_p_2 bias_p_2 source_pmos source_pmos pmos
M31 bias_p_3 bias_p_3 source_pmos source_pmos pmos
M32 bias_p_3 bias_n_1b source_nmos source_nmos nmos
M33 net_3 bias_n_1b source_nmos source_nmos nmos
M34 bias_p_2 bias_n_1b source_nmos source_nmos nmos
Cap_load_1 out1 source_nmos
Cap_load_2 out2 source_nmos
Cap_compensation_1 out1firststage out1
Cap_compensation_2 out2firststage out2
.end two_stage_fully_differential_op_amp503
