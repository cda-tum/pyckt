.suckt  two_stage_fully_differential_op_amp290 ibias in1 in2 out source_nmos source_pmos
M1 out1firststage in1 net_0 net_0 pmos
M2 out2firststage in2 net_0 net_0 pmos
M3 out1firststage outfeedback source_nmos source_nmos nmos
M4 out2firststage outfeedback source_nmos source_nmos nmos
M5 net_1 ibias source_pmos source_pmos pmos
M6 net_0 bias_p_2 net_1 net_1 pmos
M7 net_4 out2 net_5 net_5 pmos
M8 outfeedback vref net_5 net_5 pmos
M9 net_4 out1 net_6 net_6 pmos
M10 outfeedback vref net_6 net_6 pmos
M11 net_4 net_4 source_nmos source_nmos nmos
M12 outfeedback outfeedback source_nmos source_nmos nmos
M13 net_5 ibias source_pmos source_pmos pmos
M14 net_6 ibias source_pmos source_pmos pmos
M15 out1 ibias source_pmos source_pmos pmos
M16 net_9 out1firststage source_nmos source_nmos nmos
M17 out1 bias_n_1 net_9 net_9 nmos
M18 out2 ibias source_pmos source_pmos pmos
M19 net_12 out2firststage source_nmos source_nmos nmos
M20 out2 bias_n_1 net_12 net_12 nmos
M21 bias_n_1 bias_n_1 source_nmos source_nmos nmos
M22 bias_p_2 bias_p_2 source_pmos source_pmos pmos
M23 ibias ibias source_pmos source_pmos pmos
M24 bias_n_4 bias_n_4 source_nmos source_nmos nmos
M25 bias_n_1 ibias source_pmos source_pmos pmos
M26 bias_p_2 bias_n_4 source_nmos source_nmos nmos
M27 bias_n_4 ibias source_pmos source_pmos pmos
Cap_load_1 out1 source_nmos
Cap_load_2 out2 source_nmos
Cap_compensation_1 out1firststage out1
Cap_compensation_2 out2firststage out2
.end two_stage_fully_differential_op_amp290
