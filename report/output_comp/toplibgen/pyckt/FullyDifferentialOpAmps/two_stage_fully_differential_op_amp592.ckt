.suckt  two_stage_fully_differential_op_amp592 ibias in1 in2 out source_nmos source_pmos
M1 out1firststage in1 net_0 net_0 nmos
M2 out2firststage in2 net_0 net_0 nmos
M3 out1firststage outfeedback source_pmos source_pmos pmos
M4 out2firststage outfeedback source_pmos source_pmos pmos
M5 net_1 bias_n_2 source_nmos source_nmos nmos
M6 net_0 bias_n_1 net_1 net_1 nmos
M7 net_4 out2 net_5 net_5 nmos
M8 outfeedback vref net_5 net_5 nmos
M9 net_4 out1 net_6 net_6 nmos
M10 outfeedback vref net_6 net_6 nmos
M11 net_4 net_4 source_pmos source_pmos pmos
M12 outfeedback outfeedback source_pmos source_pmos pmos
M13 net_7 bias_n_2 source_nmos source_nmos nmos
M14 net_5 bias_n_1 net_7 net_7 nmos
M15 net_10 bias_n_2 source_nmos source_nmos nmos
M16 net_6 bias_n_1 net_10 net_10 nmos
M17 net_11 bias_p_3b source_pmos source_pmos pmos
M18 out1 ibias net_11 net_11 pmos
M19 net_14 out1firststage source_nmos source_nmos nmos
M20 out1 bias_n_1 net_14 net_14 nmos
M21 net_16 bias_p_3b source_pmos source_pmos pmos
M22 out2 ibias net_16 net_16 pmos
M23 net_19 out2firststage source_nmos source_nmos nmos
M24 out2 bias_n_1 net_19 net_19 nmos
M25 bias_n_1 bias_n_1 source_nmos source_nmos nmos
M26 bias_n_2 bias_n_2 source_nmos source_nmos nmos
M27 bias_p_3b bias_p_3b source_pmos source_pmos pmos
M28 ibias ibias bias_p_3b bias_p_3b pmos
M29 bias_n_2 bias_p_3b source_pmos source_pmos pmos
M30 bias_n_1 bias_p_3b source_pmos source_pmos pmos
Cap_load_1 out1 source_nmos
Cap_load_2 out2 source_nmos
Cap_compensation_1 out1firststage out1
Cap_compensation_2 out2firststage out2
.end two_stage_fully_differential_op_amp592
