.suckt  two_stage_fully_differential_op_amp73 ibias in1 in2 out source_nmos source_pmos
M1 net_0 in1 net_1 net_1 pmos
M2 net_2 in2 net_1 net_1 pmos
M3 net_0 outfeedback source_nmos source_nmos nmos
M4 out1firststage bias_n_1 net_0 net_0 nmos
M5 net_2 outfeedback source_nmos source_nmos nmos
M6 out2firststage bias_n_1 net_2 net_2 nmos
M7 net_4 ibias source_pmos source_pmos pmos
M8 out1firststage bias_p_2 net_4 net_4 pmos
M9 net_7 ibias source_pmos source_pmos pmos
M10 out2firststage bias_p_2 net_7 net_7 pmos
M11 net_1 ibias source_pmos source_pmos pmos
M12 net_9 out2 net_10 net_10 pmos
M13 outfeedback vref net_10 net_10 pmos
M14 net_9 out1 net_11 net_11 pmos
M15 outfeedback vref net_11 net_11 pmos
M16 net_9 net_9 source_nmos source_nmos nmos
M17 outfeedback outfeedback source_nmos source_nmos nmos
M18 net_10 ibias source_pmos source_pmos pmos
M19 net_11 ibias source_pmos source_pmos pmos
M20 out1 ibias source_pmos source_pmos pmos
M21 out1 out1firststage source_nmos source_nmos nmos
M22 out2 ibias source_pmos source_pmos pmos
M23 out2 out2firststage source_nmos source_nmos nmos
M24 bias_n_1 bias_n_1 source_nmos source_nmos nmos
M25 bias_p_2 bias_p_2 source_pmos source_pmos pmos
M26 ibias ibias source_pmos source_pmos pmos
M27 bias_n_4 bias_n_4 source_nmos source_nmos nmos
M28 bias_n_1 ibias source_pmos source_pmos pmos
M29 bias_p_2 bias_n_4 source_nmos source_nmos nmos
M30 bias_n_4 ibias source_pmos source_pmos pmos
Cap_load_1 out1 source_nmos
Cap_load_2 out2 source_nmos
Cap_compensation_1 out1firststage out1
Cap_compensation_2 out2firststage out2
.end two_stage_fully_differential_op_amp73
