.suckt  two_stage_fully_differential_op_amp516 ibias in1 in2 out source_nmos source_pmos
M1 net_0 in1 net_1 net_1 pmos
M2 net_2 in2 net_1 net_1 pmos
M3 out1firststage net_3 net_0 net_0 pmos
M4 out2firststage net_3 net_2 net_2 pmos
M5 out1firststage outfeedback source_nmos source_nmos nmos
M6 out2firststage outfeedback source_nmos source_nmos nmos
M7 net_4 net_4 source_pmos source_pmos pmos
M8 net_1 net_5 net_4 net_4 pmos
M9 net_6 out2 net_7 net_7 pmos
M10 outfeedback vref net_7 net_7 pmos
M11 net_6 out1 net_8 net_8 pmos
M12 outfeedback vref net_8 net_8 pmos
M13 net_6 net_6 source_nmos source_nmos nmos
M14 outfeedback outfeedback source_nmos source_nmos nmos
M15 net_7 bias_p_5 source_pmos source_pmos pmos
M16 net_8 bias_p_5 source_pmos source_pmos pmos
M17 net_10 out1firststage source_pmos source_pmos pmos
M18 out1 bias_p_4 net_10 net_10 pmos
M19 net_12 net_12 source_nmos source_nmos nmos
M20 out1 net_13 net_12 net_12 nmos
M21 net_14 out2firststage source_pmos source_pmos pmos
M22 out2 bias_p_4 net_14 net_14 pmos
M23 net_16 net_16 source_nmos source_nmos nmos
M24 out2 ibias net_16 net_16 nmos
M25 net_13 net_13 bias_n_1m bias_n_1m nmos
M26 bias_n_1m net_12 source_nmos source_nmos nmos
M27 ibias ibias bias_n_2m bias_n_2m nmos
M28 bias_n_2m net_16 source_nmos source_nmos nmos
M29 net_3 net_3 net_1 net_1 pmos
M30 net_5 net_5 bias_p_3m bias_p_3m pmos
M31 bias_p_3m net_4 source_pmos source_pmos pmos
M32 bias_p_4 bias_p_4 source_pmos source_pmos pmos
M33 bias_p_5 bias_p_5 source_pmos source_pmos pmos
M34 bias_p_5 net_16 source_nmos source_nmos nmos
M35 net_3 net_16 source_nmos source_nmos nmos
M36 bias_p_4 net_16 source_nmos source_nmos nmos
M37 net_13 bias_p_5 source_pmos source_pmos pmos
M38 net_5 net_16 source_nmos source_nmos nmos
Cap_load_1 out1 source_nmos
Cap_load_2 out2 source_nmos
Cap_compensation_1 out1firststage out1
Cap_compensation_2 out2firststage out2
.end two_stage_fully_differential_op_amp516
