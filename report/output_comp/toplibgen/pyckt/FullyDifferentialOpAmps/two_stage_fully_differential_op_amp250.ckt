.suckt  two_stage_fully_differential_op_amp250 ibias in1 in2 out source_nmos source_pmos
M1 net_0 in1 net_1 net_1 nmos
M2 net_2 in2 net_1 net_1 nmos
M3 out1firststage net_3 net_0 net_0 nmos
M4 out2firststage net_3 net_2 net_2 nmos
M5 out1firststage outfeedback source_pmos source_pmos pmos
M6 out2firststage outfeedback source_pmos source_pmos pmos
M7 net_1 ibias source_nmos source_nmos nmos
M8 net_5 out2 net_6 net_6 nmos
M9 outfeedback vref net_6 net_6 nmos
M10 net_5 out1 net_7 net_7 nmos
M11 outfeedback vref net_7 net_7 nmos
M12 net_5 net_5 source_pmos source_pmos pmos
M13 outfeedback outfeedback source_pmos source_pmos pmos
M14 net_6 ibias source_nmos source_nmos nmos
M15 net_7 ibias source_nmos source_nmos nmos
M16 net_9 out1firststage source_pmos source_pmos pmos
M17 out1 bias_p_2 net_9 net_9 pmos
M18 out1 ibias source_nmos source_nmos nmos
M19 net_12 out2firststage source_pmos source_pmos pmos
M20 out2 bias_p_2 net_12 net_12 pmos
M21 out2 ibias source_nmos source_nmos nmos
M22 net_3 net_3 net_1 net_1 nmos
M23 ibias ibias source_nmos source_nmos nmos
M24 bias_p_2 bias_p_2 source_pmos source_pmos pmos
M25 bias_p_3 bias_p_3 source_pmos source_pmos pmos
M26 net_3 bias_p_3 source_pmos source_pmos pmos
M27 bias_p_2 ibias source_nmos source_nmos nmos
M28 bias_p_3 ibias source_nmos source_nmos nmos
Cap_load_1 out1 source_nmos
Cap_load_2 out2 source_nmos
Cap_compensation_1 out1firststage out1
Cap_compensation_2 out2firststage out2
.end two_stage_fully_differential_op_amp250
