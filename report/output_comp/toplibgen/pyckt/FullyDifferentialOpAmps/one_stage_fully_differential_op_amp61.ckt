.suckt  one_stage_fully_differential_op_amp61 ibias in1 in2 out source_nmos source_pmos
M1 net_0 in1 net_1 net_1 nmos
M2 net_2 in2 net_1 net_1 nmos
M3 net_0 outfeedback source_pmos source_pmos pmos
M4 out1 bias_p_3 net_0 net_0 pmos
M5 net_2 outfeedback source_pmos source_pmos pmos
M6 out2 bias_p_3 net_2 net_2 pmos
M7 net_4 ibias source_nmos source_nmos nmos
M8 out1 bias_n_1 net_4 net_4 nmos
M9 net_7 ibias source_nmos source_nmos nmos
M10 out2 bias_n_1 net_7 net_7 nmos
M11 net_8 ibias source_nmos source_nmos nmos
M12 net_1 bias_n_1 net_8 net_8 nmos
M13 net_11 out2 net_12 net_12 nmos
M14 outfeedback vref net_12 net_12 nmos
M15 net_11 out1 net_13 net_13 nmos
M16 outfeedback vref net_13 net_13 nmos
M17 net_11 net_11 source_pmos source_pmos pmos
M18 outfeedback outfeedback source_pmos source_pmos pmos
M19 net_12 ibias source_nmos source_nmos nmos
M20 net_13 ibias source_nmos source_nmos nmos
M21 bias_n_1 bias_n_1 source_nmos source_nmos nmos
M22 ibias ibias source_nmos source_nmos nmos
M23 bias_p_3 bias_p_3 source_pmos source_pmos pmos
M24 bias_p_4 bias_p_4 source_pmos source_pmos pmos
M25 bias_n_1 bias_p_4 source_pmos source_pmos pmos
M26 bias_p_3 ibias source_nmos source_nmos nmos
M27 bias_p_4 ibias source_nmos source_nmos nmos
Cap_load_1 out1 source_nmos
Cap_load_2 out2 source_nmos
.end one_stage_fully_differential_op_amp61
