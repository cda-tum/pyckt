.suckt  two_stage_fully_differential_op_amp14 ibias in1 in2 out source_nmos source_pmos
M1 out1firststage in1 net_0 net_0 pmos
M2 out2firststage in2 net_0 net_0 pmos
M3 out1firststage outfeedback source_nmos source_nmos nmos
M4 out2firststage outfeedback source_nmos source_nmos nmos
M5 net_0 ibias source_pmos source_pmos pmos
M6 net_2 out2 net_3 net_3 pmos
M7 outfeedback vref net_3 net_3 pmos
M8 net_2 out1 net_4 net_4 pmos
M9 outfeedback vref net_4 net_4 pmos
M10 net_2 net_2 source_nmos source_nmos nmos
M11 outfeedback outfeedback source_nmos source_nmos nmos
M12 net_5 ibias source_pmos source_pmos pmos
M13 net_3 bias_p_2 net_5 net_5 pmos
M14 net_8 ibias source_pmos source_pmos pmos
M15 net_4 bias_p_2 net_8 net_8 pmos
M16 out1 ibias source_pmos source_pmos pmos
M17 net_10 out1firststage source_nmos source_nmos nmos
M18 out1 bias_n_1 net_10 net_10 nmos
M19 out2 ibias source_pmos source_pmos pmos
M20 net_13 out2firststage source_nmos source_nmos nmos
M21 out2 bias_n_1 net_13 net_13 nmos
M22 bias_n_1 bias_n_1 source_nmos source_nmos nmos
M23 bias_p_2 bias_p_2 source_pmos source_pmos pmos
M24 ibias ibias source_pmos source_pmos pmos
M25 bias_n_4 bias_n_4 source_nmos source_nmos nmos
M26 bias_n_1 ibias source_pmos source_pmos pmos
M27 bias_p_2 bias_n_4 source_nmos source_nmos nmos
M28 bias_n_4 ibias source_pmos source_pmos pmos
Cap_load_1 out1 source_nmos
Cap_load_2 out2 source_nmos
Cap_compensation_1 out1firststage out1
Cap_compensation_2 out2firststage out2
.end two_stage_fully_differential_op_amp14
