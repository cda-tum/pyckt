.suckt  two_stage_fully_differential_op_amp760 ibias in1 in2 out source_nmos source_pmos
M1 net_0 in1 net_1 net_1 nmos
M2 net_2 in2 net_1 net_1 nmos
M3 net_0 outfeedback source_pmos source_pmos pmos
M4 out1firststage bias_p_4 net_0 net_0 pmos
M5 net_2 outfeedback source_pmos source_pmos pmos
M6 out2firststage bias_p_4 net_2 net_2 pmos
M7 net_4 bias_n_3 source_nmos source_nmos nmos
M8 out1firststage bias_n_2 net_4 net_4 nmos
M9 net_7 bias_n_3 source_nmos source_nmos nmos
M10 out2firststage bias_n_2 net_7 net_7 nmos
M11 net_8 net_8 source_nmos source_nmos nmos
M12 net_1 net_9 net_8 net_8 nmos
M13 net_10 out2 net_11 net_11 nmos
M14 outfeedback vref net_11 net_11 nmos
M15 net_10 out1 net_12 net_12 nmos
M16 outfeedback vref net_12 net_12 nmos
M17 net_10 net_10 source_pmos source_pmos pmos
M18 outfeedback outfeedback source_pmos source_pmos pmos
M19 net_13 bias_n_3 source_nmos source_nmos nmos
M20 net_11 bias_n_2 net_13 net_13 nmos
M21 net_16 bias_n_3 source_nmos source_nmos nmos
M22 net_12 bias_n_2 net_16 net_16 nmos
M23 net_17 ibias source_pmos source_pmos pmos
M24 out1 bias_p_4 net_17 net_17 pmos
M25 net_20 out1firststage source_nmos source_nmos nmos
M26 out1 bias_n_2 net_20 net_20 nmos
M27 net_22 ibias source_pmos source_pmos pmos
M28 out2 bias_p_4 net_22 net_22 pmos
M29 net_25 out2firststage source_nmos source_nmos nmos
M30 out2 bias_n_2 net_25 net_25 nmos
M31 net_9 net_9 bias_n_1m bias_n_1m nmos
M32 bias_n_1m net_8 source_nmos source_nmos nmos
M33 bias_n_2 bias_n_2 source_nmos source_nmos nmos
M34 bias_n_3 bias_n_3 source_nmos source_nmos nmos
M35 bias_p_4 bias_p_4 source_pmos source_pmos pmos
M36 ibias ibias source_pmos source_pmos pmos
M37 bias_n_3 ibias source_pmos source_pmos pmos
M38 bias_n_2 ibias source_pmos source_pmos pmos
M39 bias_p_4 bias_n_3 source_nmos source_nmos nmos
M40 net_9 ibias source_pmos source_pmos pmos
Cap_load_1 out1 source_nmos
Cap_load_2 out2 source_nmos
Cap_compensation_1 out1firststage out1
Cap_compensation_2 out2firststage out2
.end two_stage_fully_differential_op_amp760
