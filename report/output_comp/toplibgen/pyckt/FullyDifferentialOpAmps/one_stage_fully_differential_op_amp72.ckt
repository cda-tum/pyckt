.suckt  one_stage_fully_differential_op_amp72 ibias in1 in2 out source_nmos source_pmos
M1 net_0 in1 net_1 net_1 nmos
M2 net_2 in2 net_1 net_1 nmos
M3 out1 net_3 net_0 net_0 nmos
M4 out2 net_3 net_2 net_2 nmos
M5 net_4 outfeedback source_pmos source_pmos pmos
M6 out1 bias_p_3 net_4 net_4 pmos
M7 net_6 outfeedback source_pmos source_pmos pmos
M8 out2 bias_p_3 net_6 net_6 pmos
M9 net_7 net_7 source_nmos source_nmos nmos
M10 net_1 net_8 net_7 net_7 nmos
M11 net_9 out2 net_10 net_10 nmos
M12 outfeedback vref net_10 net_10 nmos
M13 net_9 out1 net_11 net_11 nmos
M14 outfeedback vref net_11 net_11 nmos
M15 net_9 net_9 source_pmos source_pmos pmos
M16 outfeedback outfeedback source_pmos source_pmos pmos
M17 net_12 bias_n_2b source_nmos source_nmos nmos
M18 net_10 ibias net_12 net_12 nmos
M19 net_15 bias_n_2b source_nmos source_nmos nmos
M20 net_11 ibias net_15 net_15 nmos
M21 net_3 net_3 net_1 net_1 nmos
M22 net_8 net_8 bias_n_1m bias_n_1m nmos
M23 bias_n_1m net_7 source_nmos source_nmos nmos
M24 bias_n_2b bias_n_2b source_nmos source_nmos nmos
M25 ibias ibias bias_n_2b bias_n_2b nmos
M26 bias_p_3 bias_p_3 source_pmos source_pmos pmos
M27 bias_p_4 bias_p_4 source_pmos source_pmos pmos
M28 net_3 bias_p_4 source_pmos source_pmos pmos
M29 bias_p_3 bias_n_2b source_nmos source_nmos nmos
M30 net_8 bias_p_4 source_pmos source_pmos pmos
M31 bias_p_4 bias_n_2b source_nmos source_nmos nmos
Cap_load_1 out1 source_nmos
Cap_load_2 out2 source_nmos
.end one_stage_fully_differential_op_amp72
