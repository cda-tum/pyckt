.suckt  two_stage_fully_differential_op_amp381 ibias in1 in2 out source_nmos source_pmos
M1 out1firststage in1 net_0 net_0 pmos
M2 out2firststage in2 net_0 net_0 pmos
M3 net_1 outfeedback source_nmos source_nmos nmos
M4 out1firststage bias_n_3 net_1 net_1 nmos
M5 net_3 outfeedback source_nmos source_nmos nmos
M6 out2firststage bias_n_3 net_3 net_3 nmos
M7 net_4 net_4 source_pmos source_pmos pmos
M8 net_0 net_5 net_4 net_4 pmos
M9 net_6 out2 net_7 net_7 pmos
M10 outfeedback vref net_7 net_7 pmos
M11 net_6 out1 net_8 net_8 pmos
M12 outfeedback vref net_8 net_8 pmos
M13 net_6 net_6 source_nmos source_nmos nmos
M14 outfeedback outfeedback source_nmos source_nmos nmos
M15 net_9 bias_p_5b source_pmos source_pmos pmos
M16 net_7 ibias net_9 net_9 pmos
M17 net_12 bias_p_5b source_pmos source_pmos pmos
M18 net_8 ibias net_12 net_12 pmos
M19 out1 out1firststage source_pmos source_pmos pmos
M20 net_13 net_13 source_nmos source_nmos nmos
M21 out1 net_14 net_13 net_13 nmos
M22 out2 out2firststage source_pmos source_pmos pmos
M23 net_15 net_15 source_nmos source_nmos nmos
M24 out2 net_16 net_15 net_15 nmos
M25 net_14 net_14 bias_n_1m bias_n_1m nmos
M26 bias_n_1m net_13 source_nmos source_nmos nmos
M27 net_16 net_16 bias_n_2m bias_n_2m nmos
M28 bias_n_2m net_15 source_nmos source_nmos nmos
M29 bias_n_3 bias_n_3 source_nmos source_nmos nmos
M30 net_5 net_5 bias_p_4m bias_p_4m pmos
M31 bias_p_4m net_4 source_pmos source_pmos pmos
M32 bias_p_5b bias_p_5b source_pmos source_pmos pmos
M33 ibias ibias bias_p_5b bias_p_5b pmos
M34 bias_n_6 bias_n_6 source_nmos source_nmos nmos
M35 net_16 bias_p_5b source_pmos source_pmos pmos
M36 bias_n_3 bias_p_5b source_pmos source_pmos pmos
M37 net_14 bias_p_5b source_pmos source_pmos pmos
M38 net_5 bias_n_6 source_nmos source_nmos nmos
M39 bias_n_6 bias_p_5b source_pmos source_pmos pmos
Cap_load_1 out1 source_nmos
Cap_load_2 out2 source_nmos
Cap_compensation_1 out1firststage out1
Cap_compensation_2 out2firststage out2
.end two_stage_fully_differential_op_amp381
