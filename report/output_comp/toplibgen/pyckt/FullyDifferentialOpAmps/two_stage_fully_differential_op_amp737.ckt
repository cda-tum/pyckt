.suckt  two_stage_fully_differential_op_amp737 ibias in1 in2 out source_nmos source_pmos
M1 net_0 in1 net_1 net_1 nmos
M2 net_2 in2 net_1 net_1 nmos
M3 net_0 outfeedback source_pmos source_pmos pmos
M4 out1firststage bias_p_4 net_0 net_0 pmos
M5 net_2 outfeedback source_pmos source_pmos pmos
M6 out2firststage bias_p_4 net_2 net_2 pmos
M7 net_4 bias_n_1b source_nmos source_nmos nmos
M8 out1firststage ibias net_4 net_4 nmos
M9 net_7 bias_n_1b source_nmos source_nmos nmos
M10 out2firststage ibias net_7 net_7 nmos
M11 net_8 bias_n_1b source_nmos source_nmos nmos
M12 net_1 ibias net_8 net_8 nmos
M13 net_11 out2 net_12 net_12 nmos
M14 outfeedback vref net_12 net_12 nmos
M15 net_11 out1 net_13 net_13 nmos
M16 outfeedback vref net_13 net_13 nmos
M17 net_11 net_11 source_pmos source_pmos pmos
M18 outfeedback outfeedback source_pmos source_pmos pmos
M19 net_14 bias_n_1b source_nmos source_nmos nmos
M20 net_12 ibias net_14 net_14 nmos
M21 net_17 bias_n_1b source_nmos source_nmos nmos
M22 net_13 ibias net_17 net_17 nmos
M23 net_18 net_18 source_pmos source_pmos pmos
M24 out1 net_19 net_18 net_18 pmos
M25 out1 out1firststage source_nmos source_nmos nmos
M26 net_20 net_20 source_pmos source_pmos pmos
M27 out2 net_21 net_20 net_20 pmos
M28 out2 out2firststage source_nmos source_nmos nmos
M29 bias_n_1b bias_n_1b source_nmos source_nmos nmos
M30 ibias ibias bias_n_1b bias_n_1b nmos
M31 net_19 net_19 bias_p_2m bias_p_2m pmos
M32 bias_p_2m net_18 source_pmos source_pmos pmos
M33 net_21 net_21 bias_p_3m bias_p_3m pmos
M34 bias_p_3m net_20 source_pmos source_pmos pmos
M35 bias_p_4 bias_p_4 source_pmos source_pmos pmos
M36 net_21 bias_n_1b source_nmos source_nmos nmos
M37 bias_p_4 bias_n_1b source_nmos source_nmos nmos
M38 net_19 bias_n_1b source_nmos source_nmos nmos
Cap_load_1 out1 source_nmos
Cap_load_2 out2 source_nmos
Cap_compensation_1 out1firststage out1
Cap_compensation_2 out2firststage out2
.end two_stage_fully_differential_op_amp737
