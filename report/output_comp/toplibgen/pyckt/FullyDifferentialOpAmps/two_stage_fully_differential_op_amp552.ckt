.suckt  two_stage_fully_differential_op_amp552 ibias in1 in2 out source_nmos source_pmos
M1 net_0 in1 net_1 net_1 pmos
M2 net_2 in2 net_1 net_1 pmos
M3 out1firststage net_3 net_0 net_0 pmos
M4 out2firststage net_3 net_2 net_2 pmos
M5 net_4 outfeedback source_nmos source_nmos nmos
M6 out1firststage bias_n_3 net_4 net_4 nmos
M7 net_6 outfeedback source_nmos source_nmos nmos
M8 out2firststage bias_n_3 net_6 net_6 nmos
M9 net_7 ibias source_pmos source_pmos pmos
M10 net_1 bias_p_4 net_7 net_7 pmos
M11 net_10 out2 net_11 net_11 pmos
M12 outfeedback vref net_11 net_11 pmos
M13 net_10 out1 net_12 net_12 pmos
M14 outfeedback vref net_12 net_12 pmos
M15 net_10 net_10 source_nmos source_nmos nmos
M16 outfeedback outfeedback source_nmos source_nmos nmos
M17 net_13 ibias source_pmos source_pmos pmos
M18 net_11 bias_p_4 net_13 net_13 pmos
M19 net_16 ibias source_pmos source_pmos pmos
M20 net_12 bias_p_4 net_16 net_16 pmos
M21 net_17 out1firststage source_pmos source_pmos pmos
M22 out1 bias_p_4 net_17 net_17 pmos
M23 net_19 net_19 source_nmos source_nmos nmos
M24 out1 net_20 net_19 net_19 nmos
M25 net_21 out2firststage source_pmos source_pmos pmos
M26 out2 bias_p_4 net_21 net_21 pmos
M27 net_23 net_23 source_nmos source_nmos nmos
M28 out2 net_24 net_23 net_23 nmos
M29 net_20 net_20 bias_n_1m bias_n_1m nmos
M30 bias_n_1m net_19 source_nmos source_nmos nmos
M31 net_24 net_24 bias_n_2m bias_n_2m nmos
M32 bias_n_2m net_23 source_nmos source_nmos nmos
M33 bias_n_3 bias_n_3 source_nmos source_nmos nmos
M34 net_3 net_3 net_1 net_1 pmos
M35 bias_p_4 bias_p_4 source_pmos source_pmos pmos
M36 ibias ibias source_pmos source_pmos pmos
M37 bias_n_6 bias_n_6 source_nmos source_nmos nmos
M38 net_24 ibias source_pmos source_pmos pmos
M39 bias_n_3 ibias source_pmos source_pmos pmos
M40 net_3 bias_n_6 source_nmos source_nmos nmos
M41 bias_p_4 bias_n_6 source_nmos source_nmos nmos
M42 net_20 ibias source_pmos source_pmos pmos
M43 bias_n_6 ibias source_pmos source_pmos pmos
Cap_load_1 out1 source_nmos
Cap_load_2 out2 source_nmos
Cap_compensation_1 out1firststage out1
Cap_compensation_2 out2firststage out2
.end two_stage_fully_differential_op_amp552
