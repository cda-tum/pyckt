.suckt  two_stage_fully_differential_op_amp324 ibias in1 in2 out source_nmos source_pmos
M1 out1firststage in1 net_0 net_0 pmos
M2 out2firststage in2 net_0 net_0 pmos
M3 out1firststage outfeedback source_nmos source_nmos nmos
M4 out2firststage outfeedback source_nmos source_nmos nmos
M5 net_1 net_1 source_pmos source_pmos pmos
M6 net_0 net_2 net_1 net_1 pmos
M7 net_3 out2 net_4 net_4 pmos
M8 outfeedback vref net_4 net_4 pmos
M9 net_3 out1 net_5 net_5 pmos
M10 outfeedback vref net_5 net_5 pmos
M11 net_3 net_3 source_nmos source_nmos nmos
M12 outfeedback outfeedback source_nmos source_nmos nmos
M13 net_4 bias_p_5 source_pmos source_pmos pmos
M14 net_5 bias_p_5 source_pmos source_pmos pmos
M15 net_7 out1firststage source_pmos source_pmos pmos
M16 out1 bias_p_4 net_7 net_7 pmos
M17 net_9 net_9 source_nmos source_nmos nmos
M18 out1 net_10 net_9 net_9 nmos
M19 net_11 out2firststage source_pmos source_pmos pmos
M20 out2 bias_p_4 net_11 net_11 pmos
M21 net_13 net_13 source_nmos source_nmos nmos
M22 out2 ibias net_13 net_13 nmos
M23 net_10 net_10 bias_n_1m bias_n_1m nmos
M24 bias_n_1m net_9 source_nmos source_nmos nmos
M25 ibias ibias bias_n_2m bias_n_2m nmos
M26 bias_n_2m net_13 source_nmos source_nmos nmos
M27 net_2 net_2 bias_p_3m bias_p_3m pmos
M28 bias_p_3m net_1 source_pmos source_pmos pmos
M29 bias_p_4 bias_p_4 source_pmos source_pmos pmos
M30 bias_p_5 bias_p_5 source_pmos source_pmos pmos
M31 bias_p_5 net_13 source_nmos source_nmos nmos
M32 bias_p_4 net_13 source_nmos source_nmos nmos
M33 net_10 bias_p_5 source_pmos source_pmos pmos
M34 net_2 net_13 source_nmos source_nmos nmos
Cap_load_1 out1 source_nmos
Cap_load_2 out2 source_nmos
Cap_compensation_1 out1firststage out1
Cap_compensation_2 out2firststage out2
.end two_stage_fully_differential_op_amp324
