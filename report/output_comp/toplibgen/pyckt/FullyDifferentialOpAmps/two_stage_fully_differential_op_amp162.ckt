.suckt  two_stage_fully_differential_op_amp162 ibias in1 in2 out source_nmos source_pmos
M1 out1firststage in1 net_0 net_0 nmos
M2 out2firststage in2 net_0 net_0 nmos
M3 out1firststage outfeedback source_pmos source_pmos pmos
M4 out2firststage outfeedback source_pmos source_pmos pmos
M5 net_0 ibias source_nmos source_nmos nmos
M6 net_2 out2 net_3 net_3 nmos
M7 outfeedback vref net_3 net_3 nmos
M8 net_2 out1 net_4 net_4 nmos
M9 outfeedback vref net_4 net_4 nmos
M10 net_2 net_2 source_pmos source_pmos pmos
M11 outfeedback outfeedback source_pmos source_pmos pmos
M12 net_5 ibias source_nmos source_nmos nmos
M13 net_3 bias_n_1 net_5 net_5 nmos
M14 net_8 ibias source_nmos source_nmos nmos
M15 net_4 bias_n_1 net_8 net_8 nmos
M16 net_9 net_9 source_pmos source_pmos pmos
M17 out1 net_10 net_9 net_9 pmos
M18 net_11 out1firststage source_nmos source_nmos nmos
M19 out1 bias_n_1 net_11 net_11 nmos
M20 net_13 net_13 source_pmos source_pmos pmos
M21 out2 net_14 net_13 net_13 pmos
M22 net_15 out2firststage source_nmos source_nmos nmos
M23 out2 bias_n_1 net_15 net_15 nmos
M24 bias_n_1 bias_n_1 source_nmos source_nmos nmos
M25 ibias ibias source_nmos source_nmos nmos
M26 net_10 net_10 bias_p_3m bias_p_3m pmos
M27 bias_p_3m net_9 source_pmos source_pmos pmos
M28 net_14 net_14 bias_p_4m bias_p_4m pmos
M29 bias_p_4m net_13 source_pmos source_pmos pmos
M30 bias_p_5 bias_p_5 source_pmos source_pmos pmos
M31 net_14 ibias source_nmos source_nmos nmos
M32 bias_n_1 bias_p_5 source_pmos source_pmos pmos
M33 net_10 ibias source_nmos source_nmos nmos
M34 bias_p_5 ibias source_nmos source_nmos nmos
Cap_load_1 out1 source_nmos
Cap_load_2 out2 source_nmos
Cap_compensation_1 out1firststage out1
Cap_compensation_2 out2firststage out2
.end two_stage_fully_differential_op_amp162
