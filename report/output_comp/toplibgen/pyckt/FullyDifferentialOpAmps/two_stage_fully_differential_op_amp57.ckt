.suckt  two_stage_fully_differential_op_amp57 ibias in1 in2 out source_nmos source_pmos
M1 net_0 in1 net_1 net_1 pmos
M2 net_2 in2 net_1 net_1 pmos
M3 net_0 outfeedback source_nmos source_nmos nmos
M4 out1firststage bias_n_3 net_0 net_0 nmos
M5 net_2 outfeedback source_nmos source_nmos nmos
M6 out2firststage bias_n_3 net_2 net_2 nmos
M7 out1firststage ibias source_pmos source_pmos pmos
M8 out2firststage ibias source_pmos source_pmos pmos
M9 net_1 ibias source_pmos source_pmos pmos
M10 net_6 out2 net_7 net_7 pmos
M11 outfeedback vref net_7 net_7 pmos
M12 net_6 out1 net_8 net_8 pmos
M13 outfeedback vref net_8 net_8 pmos
M14 net_6 net_6 source_nmos source_nmos nmos
M15 outfeedback outfeedback source_nmos source_nmos nmos
M16 net_7 ibias source_pmos source_pmos pmos
M17 net_8 ibias source_pmos source_pmos pmos
M18 out1 out1firststage source_pmos source_pmos pmos
M19 net_10 net_10 source_nmos source_nmos nmos
M20 out1 net_11 net_10 net_10 nmos
M21 out2 out2firststage source_pmos source_pmos pmos
M22 net_12 net_12 source_nmos source_nmos nmos
M23 out2 net_13 net_12 net_12 nmos
M24 net_11 net_11 bias_n_1m bias_n_1m nmos
M25 bias_n_1m net_10 source_nmos source_nmos nmos
M26 net_13 net_13 bias_n_2m bias_n_2m nmos
M27 bias_n_2m net_12 source_nmos source_nmos nmos
M28 bias_n_3 bias_n_3 source_nmos source_nmos nmos
M29 ibias ibias source_pmos source_pmos pmos
M30 net_13 ibias source_pmos source_pmos pmos
M31 bias_n_3 ibias source_pmos source_pmos pmos
M32 net_11 ibias source_pmos source_pmos pmos
Cap_load_1 out1 source_nmos
Cap_load_2 out2 source_nmos
Cap_compensation_1 out1firststage out1
Cap_compensation_2 out2firststage out2
.end two_stage_fully_differential_op_amp57
