.suckt  two_stage_fully_differential_op_amp307 ibias in1 in2 out source_nmos source_pmos
M1 out1firststage in1 net_0 net_0 pmos
M2 out2firststage in2 net_0 net_0 pmos
M3 out1firststage outfeedback source_nmos source_nmos nmos
M4 out2firststage outfeedback source_nmos source_nmos nmos
M5 net_1 bias_p_2b source_pmos source_pmos pmos
M6 net_0 ibias net_1 net_1 pmos
M7 net_4 out2 net_5 net_5 pmos
M8 outfeedback vref net_5 net_5 pmos
M9 net_4 out1 net_6 net_6 pmos
M10 outfeedback vref net_6 net_6 pmos
M11 net_4 net_4 source_nmos source_nmos nmos
M12 outfeedback outfeedback source_nmos source_nmos nmos
M13 net_7 bias_p_2b source_pmos source_pmos pmos
M14 net_5 ibias net_7 net_7 pmos
M15 net_10 bias_p_2b source_pmos source_pmos pmos
M16 net_6 ibias net_10 net_10 pmos
M17 out1 out1firststage source_pmos source_pmos pmos
M18 out1 bias_n_1 source_nmos source_nmos nmos
M19 out2 out2firststage source_pmos source_pmos pmos
M20 out2 bias_n_1 source_nmos source_nmos nmos
M21 bias_n_1 bias_n_1 source_nmos source_nmos nmos
M22 bias_p_2b bias_p_2b source_pmos source_pmos pmos
M23 ibias ibias bias_p_2b bias_p_2b pmos
M24 bias_n_1 bias_p_2b source_pmos source_pmos pmos
Cap_load_1 out1 source_nmos
Cap_load_2 out2 source_nmos
Cap_compensation_1 out1firststage out1
Cap_compensation_2 out2firststage out2
.end two_stage_fully_differential_op_amp307
