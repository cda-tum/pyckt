.suckt  one_stage_fully_differential_op_amp51 ibias in1 in2 out source_nmos source_pmos
M1 out1 in1 net_0 net_0 nmos
M2 out2 in2 net_0 net_0 nmos
M3 out1 outfeedback source_pmos source_pmos pmos
M4 out2 outfeedback source_pmos source_pmos pmos
M5 net_1 net_1 source_nmos source_nmos nmos
M6 net_0 net_2 net_1 net_1 nmos
M7 net_3 out2 net_4 net_4 nmos
M8 outfeedback vref net_4 net_4 nmos
M9 net_3 out1 net_5 net_5 nmos
M10 outfeedback vref net_5 net_5 nmos
M11 net_3 net_3 source_pmos source_pmos pmos
M12 outfeedback outfeedback source_pmos source_pmos pmos
M13 net_4 ibias source_nmos source_nmos nmos
M14 net_5 ibias source_nmos source_nmos nmos
M15 net_2 net_2 bias_n_1m bias_n_1m nmos
M16 bias_n_1m net_1 source_nmos source_nmos nmos
M17 ibias ibias source_nmos source_nmos nmos
M18 bias_p_3 bias_p_3 source_pmos source_pmos pmos
M19 net_2 bias_p_3 source_pmos source_pmos pmos
M20 bias_p_3 ibias source_nmos source_nmos nmos
Cap_load_1 out1 source_nmos
Cap_load_2 out2 source_nmos
.end one_stage_fully_differential_op_amp51
