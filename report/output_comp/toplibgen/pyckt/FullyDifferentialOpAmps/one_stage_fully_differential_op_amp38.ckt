.suckt  one_stage_fully_differential_op_amp38 ibias in1 in2 out source_nmos source_pmos
M1 net_0 in1 net_1 net_1 pmos
M2 net_2 in2 net_1 net_1 pmos
M3 net_0 outfeedback source_nmos source_nmos nmos
M4 out1 bias_n_1 net_0 net_0 nmos
M5 net_2 outfeedback source_nmos source_nmos nmos
M6 out2 bias_n_1 net_2 net_2 nmos
M7 net_4 bias_p_2b source_pmos source_pmos pmos
M8 out1 ibias net_4 net_4 pmos
M9 net_7 bias_p_2b source_pmos source_pmos pmos
M10 out2 ibias net_7 net_7 pmos
M11 net_8 bias_p_2b source_pmos source_pmos pmos
M12 net_1 ibias net_8 net_8 pmos
M13 net_11 out2 net_12 net_12 pmos
M14 outfeedback vref net_12 net_12 pmos
M15 net_11 out1 net_13 net_13 pmos
M16 outfeedback vref net_13 net_13 pmos
M17 net_11 net_11 source_nmos source_nmos nmos
M18 outfeedback outfeedback source_nmos source_nmos nmos
M19 net_14 bias_p_2b source_pmos source_pmos pmos
M20 net_12 ibias net_14 net_14 pmos
M21 net_17 bias_p_2b source_pmos source_pmos pmos
M22 net_13 ibias net_17 net_17 pmos
M23 bias_n_1 bias_n_1 source_nmos source_nmos nmos
M24 bias_p_2b bias_p_2b source_pmos source_pmos pmos
M25 ibias ibias bias_p_2b bias_p_2b pmos
M26 bias_n_1 bias_p_2b source_pmos source_pmos pmos
Cap_load_1 out1 source_nmos
Cap_load_2 out2 source_nmos
.end one_stage_fully_differential_op_amp38
