.suckt  two_stage_fully_differential_op_amp406 ibias in1 in2 out source_nmos source_pmos
M1 net_0 in1 net_1 net_1 pmos
M2 net_2 in2 net_1 net_1 pmos
M3 net_0 outfeedback source_nmos source_nmos nmos
M4 out1firststage bias_n_1 net_0 net_0 nmos
M5 net_2 outfeedback source_nmos source_nmos nmos
M6 out2firststage bias_n_1 net_2 net_2 nmos
M7 out1firststage ibias source_pmos source_pmos pmos
M8 out2firststage ibias source_pmos source_pmos pmos
M9 net_5 ibias source_pmos source_pmos pmos
M10 net_1 bias_p_3 net_5 net_5 pmos
M11 net_8 out2 net_9 net_9 pmos
M12 outfeedback vref net_9 net_9 pmos
M13 net_8 out1 net_10 net_10 pmos
M14 outfeedback vref net_10 net_10 pmos
M15 net_8 net_8 source_nmos source_nmos nmos
M16 outfeedback outfeedback source_nmos source_nmos nmos
M17 net_11 ibias source_pmos source_pmos pmos
M18 net_9 bias_p_3 net_11 net_11 pmos
M19 net_14 ibias source_pmos source_pmos pmos
M20 net_10 bias_p_3 net_14 net_14 pmos
M21 net_15 out1firststage source_pmos source_pmos pmos
M22 out1 bias_p_3 net_15 net_15 pmos
M23 out1 bias_n_2 source_nmos source_nmos nmos
M24 net_18 out2firststage source_pmos source_pmos pmos
M25 out2 bias_p_3 net_18 net_18 pmos
M26 out2 bias_n_2 source_nmos source_nmos nmos
M27 bias_n_1 bias_n_1 source_nmos source_nmos nmos
M28 bias_n_2 bias_n_2 source_nmos source_nmos nmos
M29 bias_p_3 bias_p_3 source_pmos source_pmos pmos
M30 ibias ibias source_pmos source_pmos pmos
M31 bias_n_2 ibias source_pmos source_pmos pmos
M32 bias_n_1 ibias source_pmos source_pmos pmos
M33 bias_p_3 bias_n_2 source_nmos source_nmos nmos
Cap_load_1 out1 source_nmos
Cap_load_2 out2 source_nmos
Cap_compensation_1 out1firststage out1
Cap_compensation_2 out2firststage out2
.end two_stage_fully_differential_op_amp406
