.suckt  two_stage_fully_differential_op_amp405 ibias in1 in2 out source_nmos source_pmos
M1 net_0 in1 net_1 net_1 pmos
M2 net_2 in2 net_1 net_1 pmos
M3 net_0 outfeedback source_nmos source_nmos nmos
M4 out1firststage bias_n_3 net_0 net_0 nmos
M5 net_2 outfeedback source_nmos source_nmos nmos
M6 out2firststage bias_n_3 net_2 net_2 nmos
M7 out1firststage ibias source_pmos source_pmos pmos
M8 out2firststage ibias source_pmos source_pmos pmos
M9 net_5 ibias source_pmos source_pmos pmos
M10 net_1 bias_p_4 net_5 net_5 pmos
M11 net_8 out2 net_9 net_9 pmos
M12 outfeedback vref net_9 net_9 pmos
M13 net_8 out1 net_10 net_10 pmos
M14 outfeedback vref net_10 net_10 pmos
M15 net_8 net_8 source_nmos source_nmos nmos
M16 outfeedback outfeedback source_nmos source_nmos nmos
M17 net_11 ibias source_pmos source_pmos pmos
M18 net_9 bias_p_4 net_11 net_11 pmos
M19 net_14 ibias source_pmos source_pmos pmos
M20 net_10 bias_p_4 net_14 net_14 pmos
M21 out1 out1firststage source_pmos source_pmos pmos
M22 net_15 net_15 source_nmos source_nmos nmos
M23 out1 net_16 net_15 net_15 nmos
M24 out2 out2firststage source_pmos source_pmos pmos
M25 net_17 net_17 source_nmos source_nmos nmos
M26 out2 net_18 net_17 net_17 nmos
M27 net_16 net_16 bias_n_1m bias_n_1m nmos
M28 bias_n_1m net_15 source_nmos source_nmos nmos
M29 net_18 net_18 bias_n_2m bias_n_2m nmos
M30 bias_n_2m net_17 source_nmos source_nmos nmos
M31 bias_n_3 bias_n_3 source_nmos source_nmos nmos
M32 bias_p_4 bias_p_4 source_pmos source_pmos pmos
M33 ibias ibias source_pmos source_pmos pmos
M34 bias_n_6 bias_n_6 source_nmos source_nmos nmos
M35 net_18 ibias source_pmos source_pmos pmos
M36 bias_n_3 ibias source_pmos source_pmos pmos
M37 bias_p_4 bias_n_6 source_nmos source_nmos nmos
M38 net_16 ibias source_pmos source_pmos pmos
M39 bias_n_6 ibias source_pmos source_pmos pmos
Cap_load_1 out1 source_nmos
Cap_load_2 out2 source_nmos
Cap_compensation_1 out1firststage out1
Cap_compensation_2 out2firststage out2
.end two_stage_fully_differential_op_amp405
