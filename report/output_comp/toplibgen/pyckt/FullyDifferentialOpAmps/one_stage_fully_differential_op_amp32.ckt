.suckt  one_stage_fully_differential_op_amp32 ibias in1 in2 out source_nmos source_pmos
M1 out1 in1 net_0 net_0 pmos
M2 out2 in2 net_0 net_0 pmos
M3 net_1 outfeedback source_nmos source_nmos nmos
M4 out1 bias_n_1 net_1 net_1 nmos
M5 net_3 outfeedback source_nmos source_nmos nmos
M6 out2 bias_n_1 net_3 net_3 nmos
M7 net_4 net_4 source_pmos source_pmos pmos
M8 net_0 net_5 net_4 net_4 pmos
M9 net_6 out2 net_7 net_7 pmos
M10 outfeedback vref net_7 net_7 pmos
M11 net_6 out1 net_8 net_8 pmos
M12 outfeedback vref net_8 net_8 pmos
M13 net_6 net_6 source_nmos source_nmos nmos
M14 outfeedback outfeedback source_nmos source_nmos nmos
M15 net_9 bias_p_3b source_pmos source_pmos pmos
M16 net_7 ibias net_9 net_9 pmos
M17 net_12 bias_p_3b source_pmos source_pmos pmos
M18 net_8 ibias net_12 net_12 pmos
M19 bias_n_1 bias_n_1 source_nmos source_nmos nmos
M20 net_5 net_5 bias_p_2m bias_p_2m pmos
M21 bias_p_2m net_4 source_pmos source_pmos pmos
M22 bias_p_3b bias_p_3b source_pmos source_pmos pmos
M23 ibias ibias bias_p_3b bias_p_3b pmos
M24 bias_n_4 bias_n_4 source_nmos source_nmos nmos
M25 bias_n_1 bias_p_3b source_pmos source_pmos pmos
M26 net_5 bias_n_4 source_nmos source_nmos nmos
M27 bias_n_4 bias_p_3b source_pmos source_pmos pmos
Cap_load_1 out1 source_nmos
Cap_load_2 out2 source_nmos
.end one_stage_fully_differential_op_amp32
