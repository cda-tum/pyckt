.suckt  two_stage_fully_differential_op_amp852 ibias in1 in2 out source_nmos source_pmos
M1 net_0 in1 net_1 net_1 nmos
M2 net_2 in2 net_1 net_1 nmos
M3 out1firststage net_3 net_0 net_0 nmos
M4 out2firststage net_3 net_2 net_2 nmos
M5 net_4 outfeedback source_pmos source_pmos pmos
M6 out1firststage bias_p_5 net_4 net_4 pmos
M7 net_6 outfeedback source_pmos source_pmos pmos
M8 out2firststage bias_p_5 net_6 net_6 pmos
M9 net_7 net_7 source_nmos source_nmos nmos
M10 net_1 net_8 net_7 net_7 nmos
M11 net_9 out2 net_10 net_10 nmos
M12 outfeedback vref net_10 net_10 nmos
M13 net_9 out1 net_11 net_11 nmos
M14 outfeedback vref net_11 net_11 nmos
M15 net_9 net_9 source_pmos source_pmos pmos
M16 outfeedback outfeedback source_pmos source_pmos pmos
M17 net_10 ibias source_nmos source_nmos nmos
M18 net_11 ibias source_nmos source_nmos nmos
M19 net_13 out1firststage source_pmos source_pmos pmos
M20 out1 bias_p_5 net_13 net_13 pmos
M21 net_15 net_15 source_nmos source_nmos nmos
M22 out1 net_16 net_15 net_15 nmos
M23 net_17 out2firststage source_pmos source_pmos pmos
M24 out2 bias_p_5 net_17 net_17 pmos
M25 net_19 net_19 source_nmos source_nmos nmos
M26 out2 net_20 net_19 net_19 nmos
M27 net_3 net_3 net_1 net_1 nmos
M28 net_8 net_8 bias_n_1m bias_n_1m nmos
M29 bias_n_1m net_7 source_nmos source_nmos nmos
M30 net_16 net_16 bias_n_2m bias_n_2m nmos
M31 bias_n_2m net_15 source_nmos source_nmos nmos
M32 net_20 net_20 bias_n_3m bias_n_3m nmos
M33 bias_n_3m net_19 source_nmos source_nmos nmos
M34 ibias ibias source_nmos source_nmos nmos
M35 bias_p_5 bias_p_5 source_pmos source_pmos pmos
M36 bias_p_6 bias_p_6 source_pmos source_pmos pmos
M37 net_3 bias_p_6 source_pmos source_pmos pmos
M38 bias_p_5 ibias source_nmos source_nmos nmos
M39 net_8 bias_p_6 source_pmos source_pmos pmos
M40 net_16 bias_p_6 source_pmos source_pmos pmos
M41 net_20 bias_p_6 source_pmos source_pmos pmos
M42 bias_p_6 ibias source_nmos source_nmos nmos
Cap_load_1 out1 source_nmos
Cap_load_2 out2 source_nmos
Cap_compensation_1 out1firststage out1
Cap_compensation_2 out2firststage out2
.end two_stage_fully_differential_op_amp852
