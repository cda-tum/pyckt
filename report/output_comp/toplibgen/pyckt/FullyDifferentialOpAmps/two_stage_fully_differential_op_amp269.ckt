.suckt  two_stage_fully_differential_op_amp269 ibias in1 in2 out source_nmos source_pmos
M1 net_0 in1 net_1 net_1 nmos
M2 net_2 in2 net_1 net_1 nmos
M3 out1firststage net_3 net_0 net_0 nmos
M4 out2firststage net_3 net_2 net_2 nmos
M5 net_4 outfeedback source_pmos source_pmos pmos
M6 out1firststage bias_p_4 net_4 net_4 pmos
M7 net_6 outfeedback source_pmos source_pmos pmos
M8 out2firststage bias_p_4 net_6 net_6 pmos
M9 net_1 ibias source_nmos source_nmos nmos
M10 net_8 out2 net_9 net_9 nmos
M11 outfeedback vref net_9 net_9 nmos
M12 net_8 out1 net_10 net_10 nmos
M13 outfeedback vref net_10 net_10 nmos
M14 net_8 net_8 source_pmos source_pmos pmos
M15 outfeedback outfeedback source_pmos source_pmos pmos
M16 net_9 ibias source_nmos source_nmos nmos
M17 net_10 ibias source_nmos source_nmos nmos
M18 net_12 net_12 source_pmos source_pmos pmos
M19 out1 net_13 net_12 net_12 pmos
M20 out1 out1firststage source_nmos source_nmos nmos
M21 net_14 net_14 source_pmos source_pmos pmos
M22 out2 net_15 net_14 net_14 pmos
M23 out2 out2firststage source_nmos source_nmos nmos
M24 net_3 net_3 net_1 net_1 nmos
M25 ibias ibias source_nmos source_nmos nmos
M26 net_13 net_13 bias_p_2m bias_p_2m pmos
M27 bias_p_2m net_12 source_pmos source_pmos pmos
M28 net_15 net_15 bias_p_3m bias_p_3m pmos
M29 bias_p_3m net_14 source_pmos source_pmos pmos
M30 bias_p_4 bias_p_4 source_pmos source_pmos pmos
M31 bias_p_5 bias_p_5 source_pmos source_pmos pmos
M32 net_15 ibias source_nmos source_nmos nmos
M33 net_3 bias_p_5 source_pmos source_pmos pmos
M34 bias_p_4 ibias source_nmos source_nmos nmos
M35 net_13 ibias source_nmos source_nmos nmos
M36 bias_p_5 ibias source_nmos source_nmos nmos
Cap_load_1 out1 source_nmos
Cap_load_2 out2 source_nmos
Cap_compensation_1 out1firststage out1
Cap_compensation_2 out2firststage out2
.end two_stage_fully_differential_op_amp269
