.suckt  two_stage_fully_differential_op_amp701 ibias in1 in2 out source_nmos source_pmos
M1 net_0 in1 net_1 net_1 nmos
M2 net_2 in2 net_1 net_1 nmos
M3 net_0 outfeedback source_pmos source_pmos pmos
M4 out1firststage bias_p_5 net_0 net_0 pmos
M5 net_2 outfeedback source_pmos source_pmos pmos
M6 out2firststage bias_p_5 net_2 net_2 pmos
M7 out1firststage ibias source_nmos source_nmos nmos
M8 out2firststage ibias source_nmos source_nmos nmos
M9 net_5 net_5 source_nmos source_nmos nmos
M10 net_1 net_6 net_5 net_5 nmos
M11 net_7 out2 net_8 net_8 nmos
M12 outfeedback vref net_8 net_8 nmos
M13 net_7 out1 net_9 net_9 nmos
M14 outfeedback vref net_9 net_9 nmos
M15 net_7 net_7 source_pmos source_pmos pmos
M16 outfeedback outfeedback source_pmos source_pmos pmos
M17 net_8 ibias source_nmos source_nmos nmos
M18 net_9 ibias source_nmos source_nmos nmos
M19 net_11 net_11 source_pmos source_pmos pmos
M20 out1 net_12 net_11 net_11 pmos
M21 out1 out1firststage source_nmos source_nmos nmos
M22 net_13 net_13 source_pmos source_pmos pmos
M23 out2 net_14 net_13 net_13 pmos
M24 out2 out2firststage source_nmos source_nmos nmos
M25 net_6 net_6 bias_n_1m bias_n_1m nmos
M26 bias_n_1m net_5 source_nmos source_nmos nmos
M27 ibias ibias source_nmos source_nmos nmos
M28 net_12 net_12 bias_p_3m bias_p_3m pmos
M29 bias_p_3m net_11 source_pmos source_pmos pmos
M30 net_14 net_14 bias_p_4m bias_p_4m pmos
M31 bias_p_4m net_13 source_pmos source_pmos pmos
M32 bias_p_5 bias_p_5 source_pmos source_pmos pmos
M33 bias_p_6 bias_p_6 source_pmos source_pmos pmos
M34 net_14 ibias source_nmos source_nmos nmos
M35 bias_p_5 ibias source_nmos source_nmos nmos
M36 net_6 bias_p_6 source_pmos source_pmos pmos
M37 net_12 ibias source_nmos source_nmos nmos
M38 bias_p_6 ibias source_nmos source_nmos nmos
Cap_load_1 out1 source_nmos
Cap_load_2 out2 source_nmos
Cap_compensation_1 out1firststage out1
Cap_compensation_2 out2firststage out2
.end two_stage_fully_differential_op_amp701
