.suckt  two_stage_fully_differential_op_amp226 ibias in1 in2 out source_nmos source_pmos
M1 net_0 in1 net_1 net_1 nmos
M2 net_2 in2 net_1 net_1 nmos
M3 net_0 outfeedback source_pmos source_pmos pmos
M4 out1firststage bias_p_3 net_0 net_0 pmos
M5 net_2 outfeedback source_pmos source_pmos pmos
M6 out2firststage bias_p_3 net_2 net_2 pmos
M7 net_4 ibias source_nmos source_nmos nmos
M8 out1firststage bias_n_1 net_4 net_4 nmos
M9 net_7 ibias source_nmos source_nmos nmos
M10 out2firststage bias_n_1 net_7 net_7 nmos
M11 net_1 ibias source_nmos source_nmos nmos
M12 net_9 out2 net_10 net_10 nmos
M13 outfeedback vref net_10 net_10 nmos
M14 net_9 out1 net_11 net_11 nmos
M15 outfeedback vref net_11 net_11 nmos
M16 net_9 net_9 source_pmos source_pmos pmos
M17 outfeedback outfeedback source_pmos source_pmos pmos
M18 net_10 ibias source_nmos source_nmos nmos
M19 net_11 ibias source_nmos source_nmos nmos
M20 net_13 out1firststage source_pmos source_pmos pmos
M21 out1 bias_p_3 net_13 net_13 pmos
M22 out1 ibias source_nmos source_nmos nmos
M23 net_16 out2firststage source_pmos source_pmos pmos
M24 out2 bias_p_3 net_16 net_16 pmos
M25 out2 ibias source_nmos source_nmos nmos
M26 bias_n_1 bias_n_1 source_nmos source_nmos nmos
M27 ibias ibias source_nmos source_nmos nmos
M28 bias_p_3 bias_p_3 source_pmos source_pmos pmos
M29 bias_p_4 bias_p_4 source_pmos source_pmos pmos
M30 bias_n_1 bias_p_4 source_pmos source_pmos pmos
M31 bias_p_3 ibias source_nmos source_nmos nmos
M32 bias_p_4 ibias source_nmos source_nmos nmos
Cap_load_1 out1 source_nmos
Cap_load_2 out2 source_nmos
Cap_compensation_1 out1firststage out1
Cap_compensation_2 out2firststage out2
.end two_stage_fully_differential_op_amp226
