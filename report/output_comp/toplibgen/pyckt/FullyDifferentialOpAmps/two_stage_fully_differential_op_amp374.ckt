.suckt  two_stage_fully_differential_op_amp374 ibias in1 in2 out source_nmos source_pmos
M1 out1firststage in1 net_0 net_0 pmos
M2 out2firststage in2 net_0 net_0 pmos
M3 net_1 outfeedback source_nmos source_nmos nmos
M4 out1firststage bias_n_1 net_1 net_1 nmos
M5 net_3 outfeedback source_nmos source_nmos nmos
M6 out2firststage bias_n_1 net_3 net_3 nmos
M7 net_4 net_4 source_pmos source_pmos pmos
M8 net_0 net_5 net_4 net_4 pmos
M9 net_6 out2 net_7 net_7 pmos
M10 outfeedback vref net_7 net_7 pmos
M11 net_6 out1 net_8 net_8 pmos
M12 outfeedback vref net_8 net_8 pmos
M13 net_6 net_6 source_nmos source_nmos nmos
M14 outfeedback outfeedback source_nmos source_nmos nmos
M15 net_9 ibias source_pmos source_pmos pmos
M16 net_7 bias_p_3 net_9 net_9 pmos
M17 net_12 ibias source_pmos source_pmos pmos
M18 net_8 bias_p_3 net_12 net_12 pmos
M19 out1 ibias source_pmos source_pmos pmos
M20 net_14 out1firststage source_nmos source_nmos nmos
M21 out1 bias_n_1 net_14 net_14 nmos
M22 out2 ibias source_pmos source_pmos pmos
M23 net_17 out2firststage source_nmos source_nmos nmos
M24 out2 bias_n_1 net_17 net_17 nmos
M25 bias_n_1 bias_n_1 source_nmos source_nmos nmos
M26 net_5 net_5 bias_p_2m bias_p_2m pmos
M27 bias_p_2m net_4 source_pmos source_pmos pmos
M28 bias_p_3 bias_p_3 source_pmos source_pmos pmos
M29 ibias ibias source_pmos source_pmos pmos
M30 bias_n_5 bias_n_5 source_nmos source_nmos nmos
M31 bias_n_1 ibias source_pmos source_pmos pmos
M32 bias_p_3 bias_n_5 source_nmos source_nmos nmos
M33 net_5 bias_n_5 source_nmos source_nmos nmos
M34 bias_n_5 ibias source_pmos source_pmos pmos
Cap_load_1 out1 source_nmos
Cap_load_2 out2 source_nmos
Cap_compensation_1 out1firststage out1
Cap_compensation_2 out2firststage out2
.end two_stage_fully_differential_op_amp374
