.suckt  two_stage_fully_differential_op_amp729 ibias in1 in2 out source_nmos source_pmos
M1 net_0 in1 net_1 net_1 nmos
M2 net_2 in2 net_1 net_1 nmos
M3 net_0 outfeedback source_pmos source_pmos pmos
M4 out1firststage bias_p_5 net_0 net_0 pmos
M5 net_2 outfeedback source_pmos source_pmos pmos
M6 out2firststage bias_p_5 net_2 net_2 pmos
M7 net_4 ibias source_nmos source_nmos nmos
M8 out1firststage bias_n_3 net_4 net_4 nmos
M9 net_7 ibias source_nmos source_nmos nmos
M10 out2firststage bias_n_3 net_7 net_7 nmos
M11 net_8 ibias source_nmos source_nmos nmos
M12 net_1 bias_n_3 net_8 net_8 nmos
M13 net_11 out2 net_12 net_12 nmos
M14 outfeedback vref net_12 net_12 nmos
M15 net_11 out1 net_13 net_13 nmos
M16 outfeedback vref net_13 net_13 nmos
M17 net_11 net_11 source_pmos source_pmos pmos
M18 outfeedback outfeedback source_pmos source_pmos pmos
M19 net_12 ibias source_nmos source_nmos nmos
M20 net_13 ibias source_nmos source_nmos nmos
M21 out1 out1firststage source_pmos source_pmos pmos
M22 net_15 net_15 source_nmos source_nmos nmos
M23 out1 net_16 net_15 net_15 nmos
M24 out2 out2firststage source_pmos source_pmos pmos
M25 net_17 net_17 source_nmos source_nmos nmos
M26 out2 net_18 net_17 net_17 nmos
M27 net_16 net_16 bias_n_1m bias_n_1m nmos
M28 bias_n_1m net_15 source_nmos source_nmos nmos
M29 net_18 net_18 bias_n_2m bias_n_2m nmos
M30 bias_n_2m net_17 source_nmos source_nmos nmos
M31 bias_n_3 bias_n_3 source_nmos source_nmos nmos
M32 ibias ibias source_nmos source_nmos nmos
M33 bias_p_5 bias_p_5 source_pmos source_pmos pmos
M34 bias_p_6 bias_p_6 source_pmos source_pmos pmos
M35 bias_n_3 bias_p_6 source_pmos source_pmos pmos
M36 bias_p_5 ibias source_nmos source_nmos nmos
M37 net_16 bias_p_6 source_pmos source_pmos pmos
M38 net_18 bias_p_6 source_pmos source_pmos pmos
M39 bias_p_6 ibias source_nmos source_nmos nmos
Cap_load_1 out1 source_nmos
Cap_load_2 out2 source_nmos
Cap_compensation_1 out1firststage out1
Cap_compensation_2 out2firststage out2
.end two_stage_fully_differential_op_amp729
