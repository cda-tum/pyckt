.suckt  two_stage_fully_differential_op_amp458 ibias in1 in2 out source_nmos source_pmos
M1 net_0 in1 net_1 net_1 pmos
M2 net_2 in2 net_1 net_1 pmos
M3 net_0 outfeedback source_nmos source_nmos nmos
M4 out1firststage bias_n_1 net_0 net_0 nmos
M5 net_2 outfeedback source_nmos source_nmos nmos
M6 out2firststage bias_n_1 net_2 net_2 nmos
M7 net_4 ibias source_pmos source_pmos pmos
M8 out1firststage bias_p_3 net_4 net_4 pmos
M9 net_7 ibias source_pmos source_pmos pmos
M10 out2firststage bias_p_3 net_7 net_7 pmos
M11 net_8 net_8 source_pmos source_pmos pmos
M12 net_1 net_9 net_8 net_8 pmos
M13 net_10 out2 net_11 net_11 pmos
M14 outfeedback vref net_11 net_11 pmos
M15 net_10 out1 net_12 net_12 pmos
M16 outfeedback vref net_12 net_12 pmos
M17 net_10 net_10 source_nmos source_nmos nmos
M18 outfeedback outfeedback source_nmos source_nmos nmos
M19 net_11 ibias source_pmos source_pmos pmos
M20 net_12 ibias source_pmos source_pmos pmos
M21 out1 ibias source_pmos source_pmos pmos
M22 net_15 out1firststage source_nmos source_nmos nmos
M23 out1 bias_n_1 net_15 net_15 nmos
M24 out2 ibias source_pmos source_pmos pmos
M25 net_18 out2firststage source_nmos source_nmos nmos
M26 out2 bias_n_1 net_18 net_18 nmos
M27 bias_n_1 bias_n_1 source_nmos source_nmos nmos
M28 net_9 net_9 bias_p_2m bias_p_2m pmos
M29 bias_p_2m net_8 source_pmos source_pmos pmos
M30 bias_p_3 bias_p_3 source_pmos source_pmos pmos
M31 ibias ibias source_pmos source_pmos pmos
M32 bias_n_5 bias_n_5 source_nmos source_nmos nmos
M33 bias_n_1 ibias source_pmos source_pmos pmos
M34 bias_p_3 bias_n_5 source_nmos source_nmos nmos
M35 net_9 bias_n_5 source_nmos source_nmos nmos
M36 bias_n_5 ibias source_pmos source_pmos pmos
Cap_load_1 out1 source_nmos
Cap_load_2 out2 source_nmos
Cap_compensation_1 out1firststage out1
Cap_compensation_2 out2firststage out2
.end two_stage_fully_differential_op_amp458
