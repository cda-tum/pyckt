.suckt  two_stage_fully_differential_op_amp33 ibias in1 in2 out source_nmos source_pmos
M1 out1firststage in1 net_0 net_0 pmos
M2 out2firststage in2 net_0 net_0 pmos
M3 net_1 outfeedback source_nmos source_nmos nmos
M4 out1firststage bias_n_3 net_1 net_1 nmos
M5 net_3 outfeedback source_nmos source_nmos nmos
M6 out2firststage bias_n_3 net_3 net_3 nmos
M7 net_0 ibias source_pmos source_pmos pmos
M8 net_5 out2 net_6 net_6 pmos
M9 outfeedback vref net_6 net_6 pmos
M10 net_5 out1 net_7 net_7 pmos
M11 outfeedback vref net_7 net_7 pmos
M12 net_5 net_5 source_nmos source_nmos nmos
M13 outfeedback outfeedback source_nmos source_nmos nmos
M14 net_6 ibias source_pmos source_pmos pmos
M15 net_7 ibias source_pmos source_pmos pmos
M16 out1 out1firststage source_pmos source_pmos pmos
M17 net_9 net_9 source_nmos source_nmos nmos
M18 out1 net_10 net_9 net_9 nmos
M19 out2 out2firststage source_pmos source_pmos pmos
M20 net_11 net_11 source_nmos source_nmos nmos
M21 out2 net_12 net_11 net_11 nmos
M22 net_10 net_10 bias_n_1m bias_n_1m nmos
M23 bias_n_1m net_9 source_nmos source_nmos nmos
M24 net_12 net_12 bias_n_2m bias_n_2m nmos
M25 bias_n_2m net_11 source_nmos source_nmos nmos
M26 bias_n_3 bias_n_3 source_nmos source_nmos nmos
M27 ibias ibias source_pmos source_pmos pmos
M28 net_12 ibias source_pmos source_pmos pmos
M29 bias_n_3 ibias source_pmos source_pmos pmos
M30 net_10 ibias source_pmos source_pmos pmos
Cap_load_1 out1 source_nmos
Cap_load_2 out2 source_nmos
Cap_compensation_1 out1firststage out1
Cap_compensation_2 out2firststage out2
.end two_stage_fully_differential_op_amp33
