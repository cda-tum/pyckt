.suckt  two_stage_fully_differential_op_amp11 ibias in1 in2 out source_nmos source_pmos
M1 out1firststage in1 net_0 net_0 pmos
M2 out2firststage in2 net_0 net_0 pmos
M3 out1firststage outfeedback source_nmos source_nmos nmos
M4 out2firststage outfeedback source_nmos source_nmos nmos
M5 net_0 bias_p_3 source_pmos source_pmos pmos
M6 net_2 out2 net_3 net_3 pmos
M7 outfeedback vref net_3 net_3 pmos
M8 net_2 out1 net_4 net_4 pmos
M9 outfeedback vref net_4 net_4 pmos
M10 net_2 net_2 source_nmos source_nmos nmos
M11 outfeedback outfeedback source_nmos source_nmos nmos
M12 net_3 bias_p_3 source_pmos source_pmos pmos
M13 net_4 bias_p_3 source_pmos source_pmos pmos
M14 net_6 out1firststage source_pmos source_pmos pmos
M15 out1 bias_p_2 net_6 net_6 pmos
M16 net_8 bias_n_1b source_nmos source_nmos nmos
M17 out1 ibias net_8 net_8 nmos
M18 net_11 out2firststage source_pmos source_pmos pmos
M19 out2 bias_p_2 net_11 net_11 pmos
M20 net_13 bias_n_1b source_nmos source_nmos nmos
M21 out2 ibias net_13 net_13 nmos
M22 bias_n_1b bias_n_1b source_nmos source_nmos nmos
M23 ibias ibias bias_n_1b bias_n_1b nmos
M24 bias_p_2 bias_p_2 source_pmos source_pmos pmos
M25 bias_p_3 bias_p_3 source_pmos source_pmos pmos
M26 bias_p_3 bias_n_1b source_nmos source_nmos nmos
M27 bias_p_2 bias_n_1b source_nmos source_nmos nmos
Cap_load_1 out1 source_nmos
Cap_load_2 out2 source_nmos
Cap_compensation_1 out1firststage out1
Cap_compensation_2 out2firststage out2
.end two_stage_fully_differential_op_amp11
