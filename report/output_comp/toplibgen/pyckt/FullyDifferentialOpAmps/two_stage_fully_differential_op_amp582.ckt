.suckt  two_stage_fully_differential_op_amp582 ibias in1 in2 out source_nmos source_pmos
M1 out1firststage in1 net_0 net_0 nmos
M2 out2firststage in2 net_0 net_0 nmos
M3 out1firststage outfeedback source_pmos source_pmos pmos
M4 out2firststage outfeedback source_pmos source_pmos pmos
M5 net_1 ibias source_nmos source_nmos nmos
M6 net_0 bias_n_1 net_1 net_1 nmos
M7 net_4 out2 net_5 net_5 nmos
M8 outfeedback vref net_5 net_5 nmos
M9 net_4 out1 net_6 net_6 nmos
M10 outfeedback vref net_6 net_6 nmos
M11 net_4 net_4 source_pmos source_pmos pmos
M12 outfeedback outfeedback source_pmos source_pmos pmos
M13 net_5 ibias source_nmos source_nmos nmos
M14 net_6 ibias source_nmos source_nmos nmos
M15 net_8 net_8 source_pmos source_pmos pmos
M16 out1 net_9 net_8 net_8 pmos
M17 net_10 out1firststage source_nmos source_nmos nmos
M18 out1 bias_n_1 net_10 net_10 nmos
M19 net_12 net_12 source_pmos source_pmos pmos
M20 out2 net_13 net_12 net_12 pmos
M21 net_14 out2firststage source_nmos source_nmos nmos
M22 out2 bias_n_1 net_14 net_14 nmos
M23 bias_n_1 bias_n_1 source_nmos source_nmos nmos
M24 ibias ibias source_nmos source_nmos nmos
M25 net_9 net_9 bias_p_3m bias_p_3m pmos
M26 bias_p_3m net_8 source_pmos source_pmos pmos
M27 net_13 net_13 bias_p_4m bias_p_4m pmos
M28 bias_p_4m net_12 source_pmos source_pmos pmos
M29 bias_p_5 bias_p_5 source_pmos source_pmos pmos
M30 net_13 ibias source_nmos source_nmos nmos
M31 bias_n_1 bias_p_5 source_pmos source_pmos pmos
M32 net_9 ibias source_nmos source_nmos nmos
M33 bias_p_5 ibias source_nmos source_nmos nmos
Cap_load_1 out1 source_nmos
Cap_load_2 out2 source_nmos
Cap_compensation_1 out1firststage out1
Cap_compensation_2 out2firststage out2
.end two_stage_fully_differential_op_amp582
