.suckt  two_stage_fully_differential_op_amp468 ibias in1 in2 out source_nmos source_pmos
M1 net_0 in1 net_1 net_1 pmos
M2 net_2 in2 net_1 net_1 pmos
M3 net_0 outfeedback source_nmos source_nmos nmos
M4 out1firststage bias_n_3 net_0 net_0 nmos
M5 net_2 outfeedback source_nmos source_nmos nmos
M6 out2firststage bias_n_3 net_2 net_2 nmos
M7 net_4 ibias source_pmos source_pmos pmos
M8 out1firststage bias_p_5 net_4 net_4 pmos
M9 net_7 ibias source_pmos source_pmos pmos
M10 out2firststage bias_p_5 net_7 net_7 pmos
M11 net_8 net_8 source_pmos source_pmos pmos
M12 net_1 net_9 net_8 net_8 pmos
M13 net_10 out2 net_11 net_11 pmos
M14 outfeedback vref net_11 net_11 pmos
M15 net_10 out1 net_12 net_12 pmos
M16 outfeedback vref net_12 net_12 pmos
M17 net_10 net_10 source_nmos source_nmos nmos
M18 outfeedback outfeedback source_nmos source_nmos nmos
M19 net_11 ibias source_pmos source_pmos pmos
M20 net_12 ibias source_pmos source_pmos pmos
M21 net_14 out1firststage source_pmos source_pmos pmos
M22 out1 bias_p_5 net_14 net_14 pmos
M23 net_16 net_16 source_nmos source_nmos nmos
M24 out1 net_17 net_16 net_16 nmos
M25 net_18 out2firststage source_pmos source_pmos pmos
M26 out2 bias_p_5 net_18 net_18 pmos
M27 net_20 net_20 source_nmos source_nmos nmos
M28 out2 net_21 net_20 net_20 nmos
M29 net_17 net_17 bias_n_1m bias_n_1m nmos
M30 bias_n_1m net_16 source_nmos source_nmos nmos
M31 net_21 net_21 bias_n_2m bias_n_2m nmos
M32 bias_n_2m net_20 source_nmos source_nmos nmos
M33 bias_n_3 bias_n_3 source_nmos source_nmos nmos
M34 net_9 net_9 bias_p_4m bias_p_4m pmos
M35 bias_p_4m net_8 source_pmos source_pmos pmos
M36 bias_p_5 bias_p_5 source_pmos source_pmos pmos
M37 ibias ibias source_pmos source_pmos pmos
M38 bias_n_7 bias_n_7 source_nmos source_nmos nmos
M39 net_21 ibias source_pmos source_pmos pmos
M40 bias_n_3 ibias source_pmos source_pmos pmos
M41 bias_p_5 bias_n_7 source_nmos source_nmos nmos
M42 net_17 ibias source_pmos source_pmos pmos
M43 net_9 bias_n_7 source_nmos source_nmos nmos
M44 bias_n_7 ibias source_pmos source_pmos pmos
Cap_load_1 out1 source_nmos
Cap_load_2 out2 source_nmos
Cap_compensation_1 out1firststage out1
Cap_compensation_2 out2firststage out2
.end two_stage_fully_differential_op_amp468
