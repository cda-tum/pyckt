.suckt  two_stage_fully_differential_op_amp234 ibias in1 in2 out source_nmos source_pmos
M1 net_0 in1 net_1 net_1 nmos
M2 net_2 in2 net_1 net_1 nmos
M3 net_0 outfeedback source_pmos source_pmos pmos
M4 out1firststage bias_p_5 net_0 net_0 pmos
M5 net_2 outfeedback source_pmos source_pmos pmos
M6 out2firststage bias_p_5 net_2 net_2 pmos
M7 net_4 ibias source_nmos source_nmos nmos
M8 out1firststage bias_n_1 net_4 net_4 nmos
M9 net_7 ibias source_nmos source_nmos nmos
M10 out2firststage bias_n_1 net_7 net_7 nmos
M11 net_1 ibias source_nmos source_nmos nmos
M12 net_9 out2 net_10 net_10 nmos
M13 outfeedback vref net_10 net_10 nmos
M14 net_9 out1 net_11 net_11 nmos
M15 outfeedback vref net_11 net_11 nmos
M16 net_9 net_9 source_pmos source_pmos pmos
M17 outfeedback outfeedback source_pmos source_pmos pmos
M18 net_12 ibias source_nmos source_nmos nmos
M19 net_10 bias_n_1 net_12 net_12 nmos
M20 net_15 ibias source_nmos source_nmos nmos
M21 net_11 bias_n_1 net_15 net_15 nmos
M22 net_16 net_16 source_pmos source_pmos pmos
M23 out1 net_17 net_16 net_16 pmos
M24 net_18 out1firststage source_nmos source_nmos nmos
M25 out1 bias_n_1 net_18 net_18 nmos
M26 net_20 net_20 source_pmos source_pmos pmos
M27 out2 net_21 net_20 net_20 pmos
M28 net_22 out2firststage source_nmos source_nmos nmos
M29 out2 bias_n_1 net_22 net_22 nmos
M30 bias_n_1 bias_n_1 source_nmos source_nmos nmos
M31 ibias ibias source_nmos source_nmos nmos
M32 net_17 net_17 bias_p_3m bias_p_3m pmos
M33 bias_p_3m net_16 source_pmos source_pmos pmos
M34 net_21 net_21 bias_p_4m bias_p_4m pmos
M35 bias_p_4m net_20 source_pmos source_pmos pmos
M36 bias_p_5 bias_p_5 source_pmos source_pmos pmos
M37 bias_p_6 bias_p_6 source_pmos source_pmos pmos
M38 net_21 ibias source_nmos source_nmos nmos
M39 bias_n_1 bias_p_6 source_pmos source_pmos pmos
M40 bias_p_5 ibias source_nmos source_nmos nmos
M41 net_17 ibias source_nmos source_nmos nmos
M42 bias_p_6 ibias source_nmos source_nmos nmos
Cap_load_1 out1 source_nmos
Cap_load_2 out2 source_nmos
Cap_compensation_1 out1firststage out1
Cap_compensation_2 out2firststage out2
.end two_stage_fully_differential_op_amp234
