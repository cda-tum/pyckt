.suckt  two_stage_fully_differential_op_amp256 ibias in1 in2 out source_nmos source_pmos
M1 net_0 in1 net_1 net_1 nmos
M2 net_2 in2 net_1 net_1 nmos
M3 out1firststage net_3 net_0 net_0 nmos
M4 out2firststage net_3 net_2 net_2 nmos
M5 out1firststage outfeedback source_pmos source_pmos pmos
M6 out2firststage outfeedback source_pmos source_pmos pmos
M7 net_1 bias_n_2 source_nmos source_nmos nmos
M8 net_5 out2 net_6 net_6 nmos
M9 outfeedback vref net_6 net_6 nmos
M10 net_5 out1 net_7 net_7 nmos
M11 outfeedback vref net_7 net_7 nmos
M12 net_5 net_5 source_pmos source_pmos pmos
M13 outfeedback outfeedback source_pmos source_pmos pmos
M14 net_8 bias_n_2 source_nmos source_nmos nmos
M15 net_6 bias_n_1 net_8 net_8 nmos
M16 net_11 bias_n_2 source_nmos source_nmos nmos
M17 net_7 bias_n_1 net_11 net_11 nmos
M18 net_12 bias_p_3b source_pmos source_pmos pmos
M19 out1 ibias net_12 net_12 pmos
M20 net_15 out1firststage source_nmos source_nmos nmos
M21 out1 bias_n_1 net_15 net_15 nmos
M22 net_17 bias_p_3b source_pmos source_pmos pmos
M23 out2 ibias net_17 net_17 pmos
M24 net_20 out2firststage source_nmos source_nmos nmos
M25 out2 bias_n_1 net_20 net_20 nmos
M26 net_3 net_3 net_1 net_1 nmos
M27 bias_n_1 bias_n_1 source_nmos source_nmos nmos
M28 bias_n_2 bias_n_2 source_nmos source_nmos nmos
M29 bias_p_3b bias_p_3b source_pmos source_pmos pmos
M30 ibias ibias bias_p_3b bias_p_3b pmos
M31 bias_n_2 bias_p_3b source_pmos source_pmos pmos
M32 net_3 bias_p_3b source_pmos source_pmos pmos
M33 bias_n_1 bias_p_3b source_pmos source_pmos pmos
Cap_load_1 out1 source_nmos
Cap_load_2 out2 source_nmos
Cap_compensation_1 out1firststage out1
Cap_compensation_2 out2firststage out2
.end two_stage_fully_differential_op_amp256
