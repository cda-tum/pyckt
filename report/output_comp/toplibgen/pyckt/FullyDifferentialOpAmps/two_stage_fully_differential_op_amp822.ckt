.suckt  two_stage_fully_differential_op_amp822 ibias in1 in2 out source_nmos source_pmos
M1 net_0 in1 net_1 net_1 nmos
M2 net_2 in2 net_1 net_1 nmos
M3 out1firststage net_3 net_0 net_0 nmos
M4 out2firststage net_3 net_2 net_2 nmos
M5 net_4 outfeedback source_pmos source_pmos pmos
M6 out1firststage bias_p_5 net_4 net_4 pmos
M7 net_6 outfeedback source_pmos source_pmos pmos
M8 out2firststage bias_p_5 net_6 net_6 pmos
M9 net_7 ibias source_nmos source_nmos nmos
M10 net_1 bias_n_1 net_7 net_7 nmos
M11 net_10 out2 net_11 net_11 nmos
M12 outfeedback vref net_11 net_11 nmos
M13 net_10 out1 net_12 net_12 nmos
M14 outfeedback vref net_12 net_12 nmos
M15 net_10 net_10 source_pmos source_pmos pmos
M16 outfeedback outfeedback source_pmos source_pmos pmos
M17 net_11 ibias source_nmos source_nmos nmos
M18 net_12 ibias source_nmos source_nmos nmos
M19 net_14 net_14 source_pmos source_pmos pmos
M20 out1 net_15 net_14 net_14 pmos
M21 net_16 out1firststage source_nmos source_nmos nmos
M22 out1 bias_n_1 net_16 net_16 nmos
M23 net_18 net_18 source_pmos source_pmos pmos
M24 out2 net_19 net_18 net_18 pmos
M25 net_20 out2firststage source_nmos source_nmos nmos
M26 out2 bias_n_1 net_20 net_20 nmos
M27 net_3 net_3 net_1 net_1 nmos
M28 bias_n_1 bias_n_1 source_nmos source_nmos nmos
M29 ibias ibias source_nmos source_nmos nmos
M30 net_15 net_15 bias_p_3m bias_p_3m pmos
M31 bias_p_3m net_14 source_pmos source_pmos pmos
M32 net_19 net_19 bias_p_4m bias_p_4m pmos
M33 bias_p_4m net_18 source_pmos source_pmos pmos
M34 bias_p_5 bias_p_5 source_pmos source_pmos pmos
M35 bias_p_6 bias_p_6 source_pmos source_pmos pmos
M36 net_19 ibias source_nmos source_nmos nmos
M37 net_3 bias_p_6 source_pmos source_pmos pmos
M38 bias_n_1 bias_p_6 source_pmos source_pmos pmos
M39 bias_p_5 ibias source_nmos source_nmos nmos
M40 net_15 ibias source_nmos source_nmos nmos
M41 bias_p_6 ibias source_nmos source_nmos nmos
Cap_load_1 out1 source_nmos
Cap_load_2 out2 source_nmos
Cap_compensation_1 out1firststage out1
Cap_compensation_2 out2firststage out2
.end two_stage_fully_differential_op_amp822
