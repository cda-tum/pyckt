.suckt  two_stage_fully_differential_op_amp427 ibias in1 in2 out source_nmos source_pmos
M1 net_0 in1 net_1 net_1 pmos
M2 net_2 in2 net_1 net_1 pmos
M3 net_0 outfeedback source_nmos source_nmos nmos
M4 out1firststage bias_n_1 net_0 net_0 nmos
M5 net_2 outfeedback source_nmos source_nmos nmos
M6 out2firststage bias_n_1 net_2 net_2 nmos
M7 out1firststage bias_p_5 source_pmos source_pmos pmos
M8 out2firststage bias_p_5 source_pmos source_pmos pmos
M9 net_5 net_5 source_pmos source_pmos pmos
M10 net_1 net_6 net_5 net_5 pmos
M11 net_7 out2 net_8 net_8 pmos
M12 outfeedback vref net_8 net_8 pmos
M13 net_7 out1 net_9 net_9 pmos
M14 outfeedback vref net_9 net_9 pmos
M15 net_7 net_7 source_nmos source_nmos nmos
M16 outfeedback outfeedback source_nmos source_nmos nmos
M17 net_10 bias_p_5 source_pmos source_pmos pmos
M18 net_8 bias_p_4 net_10 net_10 pmos
M19 net_13 bias_p_5 source_pmos source_pmos pmos
M20 net_9 bias_p_4 net_13 net_13 pmos
M21 out1 out1firststage source_pmos source_pmos pmos
M22 out1 ibias source_nmos source_nmos nmos
M23 out2 out2firststage source_pmos source_pmos pmos
M24 out2 ibias source_nmos source_nmos nmos
M25 bias_n_1 bias_n_1 source_nmos source_nmos nmos
M26 ibias ibias source_nmos source_nmos nmos
M27 net_6 net_6 bias_p_3m bias_p_3m pmos
M28 bias_p_3m net_5 source_pmos source_pmos pmos
M29 bias_p_4 bias_p_4 source_pmos source_pmos pmos
M30 bias_p_5 bias_p_5 source_pmos source_pmos pmos
M31 bias_p_5 ibias source_nmos source_nmos nmos
M32 bias_n_1 bias_p_5 source_pmos source_pmos pmos
M33 bias_p_4 ibias source_nmos source_nmos nmos
M34 net_6 ibias source_nmos source_nmos nmos
Cap_load_1 out1 source_nmos
Cap_load_2 out2 source_nmos
Cap_compensation_1 out1firststage out1
Cap_compensation_2 out2firststage out2
.end two_stage_fully_differential_op_amp427
