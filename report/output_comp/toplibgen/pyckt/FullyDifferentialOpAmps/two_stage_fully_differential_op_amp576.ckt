.suckt  two_stage_fully_differential_op_amp576 ibias in1 in2 out source_nmos source_pmos
M1 net_0 in1 net_1 net_1 pmos
M2 net_2 in2 net_1 net_1 pmos
M3 out1firststage net_3 net_0 net_0 pmos
M4 out2firststage net_3 net_2 net_2 pmos
M5 net_4 outfeedback source_nmos source_nmos nmos
M6 out1firststage bias_n_3 net_4 net_4 nmos
M7 net_6 outfeedback source_nmos source_nmos nmos
M8 out2firststage bias_n_3 net_6 net_6 nmos
M9 net_7 net_7 source_pmos source_pmos pmos
M10 net_1 net_8 net_7 net_7 pmos
M11 net_9 out2 net_10 net_10 pmos
M12 outfeedback vref net_10 net_10 pmos
M13 net_9 out1 net_11 net_11 pmos
M14 outfeedback vref net_11 net_11 pmos
M15 net_9 net_9 source_nmos source_nmos nmos
M16 outfeedback outfeedback source_nmos source_nmos nmos
M17 net_12 bias_p_6 source_pmos source_pmos pmos
M18 net_10 bias_p_5 net_12 net_12 pmos
M19 net_15 bias_p_6 source_pmos source_pmos pmos
M20 net_11 bias_p_5 net_15 net_15 pmos
M21 net_16 out1firststage source_pmos source_pmos pmos
M22 out1 bias_p_5 net_16 net_16 pmos
M23 net_18 net_18 source_nmos source_nmos nmos
M24 out1 net_19 net_18 net_18 nmos
M25 net_20 out2firststage source_pmos source_pmos pmos
M26 out2 bias_p_5 net_20 net_20 pmos
M27 net_22 net_22 source_nmos source_nmos nmos
M28 out2 ibias net_22 net_22 nmos
M29 net_19 net_19 bias_n_1m bias_n_1m nmos
M30 bias_n_1m net_18 source_nmos source_nmos nmos
M31 ibias ibias bias_n_2m bias_n_2m nmos
M32 bias_n_2m net_22 source_nmos source_nmos nmos
M33 bias_n_3 bias_n_3 source_nmos source_nmos nmos
M34 net_3 net_3 net_1 net_1 pmos
M35 net_8 net_8 bias_p_4m bias_p_4m pmos
M36 bias_p_4m net_7 source_pmos source_pmos pmos
M37 bias_p_5 bias_p_5 source_pmos source_pmos pmos
M38 bias_p_6 bias_p_6 source_pmos source_pmos pmos
M39 bias_p_6 net_22 source_nmos source_nmos nmos
M40 bias_n_3 bias_p_6 source_pmos source_pmos pmos
M41 net_3 net_22 source_nmos source_nmos nmos
M42 bias_p_5 net_22 source_nmos source_nmos nmos
M43 net_19 bias_p_6 source_pmos source_pmos pmos
M44 net_8 net_22 source_nmos source_nmos nmos
Cap_load_1 out1 source_nmos
Cap_load_2 out2 source_nmos
Cap_compensation_1 out1firststage out1
Cap_compensation_2 out2firststage out2
.end two_stage_fully_differential_op_amp576
