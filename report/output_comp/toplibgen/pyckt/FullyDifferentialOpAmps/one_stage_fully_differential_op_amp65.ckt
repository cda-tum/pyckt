.suckt  one_stage_fully_differential_op_amp65 ibias in1 in2 out source_nmos source_pmos
M1 net_0 in1 net_1 net_1 nmos
M2 net_2 in2 net_1 net_1 nmos
M3 out1 net_3 net_0 net_0 nmos
M4 out2 net_3 net_2 net_2 nmos
M5 out1 outfeedback source_pmos source_pmos pmos
M6 out2 outfeedback source_pmos source_pmos pmos
M7 net_4 ibias source_nmos source_nmos nmos
M8 net_1 bias_n_1 net_4 net_4 nmos
M9 net_7 out2 net_8 net_8 nmos
M10 outfeedback vref net_8 net_8 nmos
M11 net_7 out1 net_9 net_9 nmos
M12 outfeedback vref net_9 net_9 nmos
M13 net_7 net_7 source_pmos source_pmos pmos
M14 outfeedback outfeedback source_pmos source_pmos pmos
M15 net_8 ibias source_nmos source_nmos nmos
M16 net_9 ibias source_nmos source_nmos nmos
M17 net_3 net_3 net_1 net_1 nmos
M18 bias_n_1 bias_n_1 source_nmos source_nmos nmos
M19 ibias ibias source_nmos source_nmos nmos
M20 bias_p_3 bias_p_3 source_pmos source_pmos pmos
M21 net_3 bias_p_3 source_pmos source_pmos pmos
M22 bias_n_1 bias_p_3 source_pmos source_pmos pmos
M23 bias_p_3 ibias source_nmos source_nmos nmos
Cap_load_1 out1 source_nmos
Cap_load_2 out2 source_nmos
.end one_stage_fully_differential_op_amp65
