.suckt  two_stage_fully_differential_op_amp329 ibias in1 in2 out source_nmos source_pmos
M1 out1firststage in1 net_0 net_0 pmos
M2 out2firststage in2 net_0 net_0 pmos
M3 out1firststage outfeedback source_nmos source_nmos nmos
M4 out2firststage outfeedback source_nmos source_nmos nmos
M5 net_1 net_1 source_pmos source_pmos pmos
M6 net_0 net_2 net_1 net_1 pmos
M7 net_3 out2 net_4 net_4 pmos
M8 outfeedback vref net_4 net_4 pmos
M9 net_3 out1 net_5 net_5 pmos
M10 outfeedback vref net_5 net_5 pmos
M11 net_3 net_3 source_nmos source_nmos nmos
M12 outfeedback outfeedback source_nmos source_nmos nmos
M13 net_6 bias_p_4b source_pmos source_pmos pmos
M14 net_4 ibias net_6 net_6 pmos
M15 net_9 bias_p_4b source_pmos source_pmos pmos
M16 net_5 ibias net_9 net_9 pmos
M17 net_10 net_10 source_pmos source_pmos pmos
M18 out1 net_11 net_10 net_10 pmos
M19 out1 out1firststage source_nmos source_nmos nmos
M20 net_12 net_12 source_pmos source_pmos pmos
M21 out2 net_13 net_12 net_12 pmos
M22 out2 out2firststage source_nmos source_nmos nmos
M23 net_2 net_2 bias_p_1m bias_p_1m pmos
M24 bias_p_1m net_1 source_pmos source_pmos pmos
M25 net_11 net_11 bias_p_2m bias_p_2m pmos
M26 bias_p_2m net_10 source_pmos source_pmos pmos
M27 net_13 net_13 bias_p_3m bias_p_3m pmos
M28 bias_p_3m net_12 source_pmos source_pmos pmos
M29 bias_p_4b bias_p_4b source_pmos source_pmos pmos
M30 ibias ibias bias_p_4b bias_p_4b pmos
M31 bias_n_5 bias_n_5 source_nmos source_nmos nmos
M32 net_2 bias_n_5 source_nmos source_nmos nmos
M33 net_11 bias_n_5 source_nmos source_nmos nmos
M34 net_13 bias_n_5 source_nmos source_nmos nmos
M35 bias_n_5 bias_p_4b source_pmos source_pmos pmos
Cap_load_1 out1 source_nmos
Cap_load_2 out2 source_nmos
Cap_compensation_1 out1firststage out1
Cap_compensation_2 out2firststage out2
.end two_stage_fully_differential_op_amp329
