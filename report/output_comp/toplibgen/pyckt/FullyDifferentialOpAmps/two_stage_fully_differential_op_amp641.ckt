.suckt  two_stage_fully_differential_op_amp641 ibias in1 in2 out source_nmos source_pmos
M1 out1firststage in1 net_0 net_0 nmos
M2 out2firststage in2 net_0 net_0 nmos
M3 net_1 outfeedback source_pmos source_pmos pmos
M4 out1firststage bias_p_4 net_1 net_1 pmos
M5 net_3 outfeedback source_pmos source_pmos pmos
M6 out2firststage bias_p_4 net_3 net_3 pmos
M7 net_4 bias_n_1b source_nmos source_nmos nmos
M8 net_0 ibias net_4 net_4 nmos
M9 net_7 out2 net_8 net_8 nmos
M10 outfeedback vref net_8 net_8 nmos
M11 net_7 out1 net_9 net_9 nmos
M12 outfeedback vref net_9 net_9 nmos
M13 net_7 net_7 source_pmos source_pmos pmos
M14 outfeedback outfeedback source_pmos source_pmos pmos
M15 net_10 bias_n_1b source_nmos source_nmos nmos
M16 net_8 ibias net_10 net_10 nmos
M17 net_13 bias_n_1b source_nmos source_nmos nmos
M18 net_9 ibias net_13 net_13 nmos
M19 net_14 net_14 source_pmos source_pmos pmos
M20 out1 net_15 net_14 net_14 pmos
M21 out1 out1firststage source_nmos source_nmos nmos
M22 net_16 net_16 source_pmos source_pmos pmos
M23 out2 net_17 net_16 net_16 pmos
M24 out2 out2firststage source_nmos source_nmos nmos
M25 bias_n_1b bias_n_1b source_nmos source_nmos nmos
M26 ibias ibias bias_n_1b bias_n_1b nmos
M27 net_15 net_15 bias_p_2m bias_p_2m pmos
M28 bias_p_2m net_14 source_pmos source_pmos pmos
M29 net_17 net_17 bias_p_3m bias_p_3m pmos
M30 bias_p_3m net_16 source_pmos source_pmos pmos
M31 bias_p_4 bias_p_4 source_pmos source_pmos pmos
M32 net_17 bias_n_1b source_nmos source_nmos nmos
M33 bias_p_4 bias_n_1b source_nmos source_nmos nmos
M34 net_15 bias_n_1b source_nmos source_nmos nmos
Cap_load_1 out1 source_nmos
Cap_load_2 out2 source_nmos
Cap_compensation_1 out1firststage out1
Cap_compensation_2 out2firststage out2
.end two_stage_fully_differential_op_amp641
