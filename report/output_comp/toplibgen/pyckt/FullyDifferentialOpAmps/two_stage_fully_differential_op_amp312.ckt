.suckt  two_stage_fully_differential_op_amp312 ibias in1 in2 out source_nmos source_pmos
M1 out1firststage in1 net_0 net_0 pmos
M2 out2firststage in2 net_0 net_0 pmos
M3 out1firststage outfeedback source_nmos source_nmos nmos
M4 out2firststage outfeedback source_nmos source_nmos nmos
M5 net_1 ibias source_pmos source_pmos pmos
M6 net_0 bias_p_3 net_1 net_1 pmos
M7 net_4 out2 net_5 net_5 pmos
M8 outfeedback vref net_5 net_5 pmos
M9 net_4 out1 net_6 net_6 pmos
M10 outfeedback vref net_6 net_6 pmos
M11 net_4 net_4 source_nmos source_nmos nmos
M12 outfeedback outfeedback source_nmos source_nmos nmos
M13 net_7 ibias source_pmos source_pmos pmos
M14 net_5 bias_p_3 net_7 net_7 pmos
M15 net_10 ibias source_pmos source_pmos pmos
M16 net_6 bias_p_3 net_10 net_10 pmos
M17 net_11 out1firststage source_pmos source_pmos pmos
M18 out1 bias_p_3 net_11 net_11 pmos
M19 net_13 net_13 source_nmos source_nmos nmos
M20 out1 net_14 net_13 net_13 nmos
M21 net_15 out2firststage source_pmos source_pmos pmos
M22 out2 bias_p_3 net_15 net_15 pmos
M23 net_17 net_17 source_nmos source_nmos nmos
M24 out2 net_18 net_17 net_17 nmos
M25 net_14 net_14 bias_n_1m bias_n_1m nmos
M26 bias_n_1m net_13 source_nmos source_nmos nmos
M27 net_18 net_18 bias_n_2m bias_n_2m nmos
M28 bias_n_2m net_17 source_nmos source_nmos nmos
M29 bias_p_3 bias_p_3 source_pmos source_pmos pmos
M30 ibias ibias source_pmos source_pmos pmos
M31 bias_n_5 bias_n_5 source_nmos source_nmos nmos
M32 net_18 ibias source_pmos source_pmos pmos
M33 bias_p_3 bias_n_5 source_nmos source_nmos nmos
M34 net_14 ibias source_pmos source_pmos pmos
M35 bias_n_5 ibias source_pmos source_pmos pmos
Cap_load_1 out1 source_nmos
Cap_load_2 out2 source_nmos
Cap_compensation_1 out1firststage out1
Cap_compensation_2 out2firststage out2
.end two_stage_fully_differential_op_amp312
