.suckt  two_stage_fully_differential_op_amp725 ibias in1 in2 out source_nmos source_pmos
M1 net_0 in1 net_1 net_1 nmos
M2 net_2 in2 net_1 net_1 nmos
M3 net_0 outfeedback source_pmos source_pmos pmos
M4 out1firststage bias_p_5 net_0 net_0 pmos
M5 net_2 outfeedback source_pmos source_pmos pmos
M6 out2firststage bias_p_5 net_2 net_2 pmos
M7 net_4 ibias source_nmos source_nmos nmos
M8 out1firststage bias_n_1 net_4 net_4 nmos
M9 net_7 ibias source_nmos source_nmos nmos
M10 out2firststage bias_n_1 net_7 net_7 nmos
M11 net_8 ibias source_nmos source_nmos nmos
M12 net_1 bias_n_1 net_8 net_8 nmos
M13 net_11 out2 net_12 net_12 nmos
M14 outfeedback vref net_12 net_12 nmos
M15 net_11 out1 net_13 net_13 nmos
M16 outfeedback vref net_13 net_13 nmos
M17 net_11 net_11 source_pmos source_pmos pmos
M18 outfeedback outfeedback source_pmos source_pmos pmos
M19 net_12 ibias source_nmos source_nmos nmos
M20 net_13 ibias source_nmos source_nmos nmos
M21 net_15 net_15 source_pmos source_pmos pmos
M22 out1 net_16 net_15 net_15 pmos
M23 out1 out1firststage source_nmos source_nmos nmos
M24 net_17 net_17 source_pmos source_pmos pmos
M25 out2 net_18 net_17 net_17 pmos
M26 out2 out2firststage source_nmos source_nmos nmos
M27 bias_n_1 bias_n_1 source_nmos source_nmos nmos
M28 ibias ibias source_nmos source_nmos nmos
M29 net_16 net_16 bias_p_3m bias_p_3m pmos
M30 bias_p_3m net_15 source_pmos source_pmos pmos
M31 net_18 net_18 bias_p_4m bias_p_4m pmos
M32 bias_p_4m net_17 source_pmos source_pmos pmos
M33 bias_p_5 bias_p_5 source_pmos source_pmos pmos
M34 bias_p_6 bias_p_6 source_pmos source_pmos pmos
M35 net_18 ibias source_nmos source_nmos nmos
M36 bias_n_1 bias_p_6 source_pmos source_pmos pmos
M37 bias_p_5 ibias source_nmos source_nmos nmos
M38 net_16 ibias source_nmos source_nmos nmos
M39 bias_p_6 ibias source_nmos source_nmos nmos
Cap_load_1 out1 source_nmos
Cap_load_2 out2 source_nmos
Cap_compensation_1 out1firststage out1
Cap_compensation_2 out2firststage out2
.end two_stage_fully_differential_op_amp725
