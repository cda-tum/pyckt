.suckt  two_stage_fully_differential_op_amp589 ibias in1 in2 out source_nmos source_pmos
M1 out1firststage in1 net_0 net_0 nmos
M2 out2firststage in2 net_0 net_0 nmos
M3 out1firststage outfeedback source_pmos source_pmos pmos
M4 out2firststage outfeedback source_pmos source_pmos pmos
M5 net_1 bias_n_1b source_nmos source_nmos nmos
M6 net_0 ibias net_1 net_1 nmos
M7 net_4 out2 net_5 net_5 nmos
M8 outfeedback vref net_5 net_5 nmos
M9 net_4 out1 net_6 net_6 nmos
M10 outfeedback vref net_6 net_6 nmos
M11 net_4 net_4 source_pmos source_pmos pmos
M12 outfeedback outfeedback source_pmos source_pmos pmos
M13 net_7 bias_n_1b source_nmos source_nmos nmos
M14 net_5 ibias net_7 net_7 nmos
M15 net_10 bias_n_1b source_nmos source_nmos nmos
M16 net_6 ibias net_10 net_10 nmos
M17 out1 bias_p_2 source_pmos source_pmos pmos
M18 out1 out1firststage source_nmos source_nmos nmos
M19 out2 bias_p_2 source_pmos source_pmos pmos
M20 out2 out2firststage source_nmos source_nmos nmos
M21 bias_n_1b bias_n_1b source_nmos source_nmos nmos
M22 ibias ibias bias_n_1b bias_n_1b nmos
M23 bias_p_2 bias_p_2 source_pmos source_pmos pmos
M24 bias_p_2 bias_n_1b source_nmos source_nmos nmos
Cap_load_1 out1 source_nmos
Cap_load_2 out2 source_nmos
Cap_compensation_1 out1firststage out1
Cap_compensation_2 out2firststage out2
.end two_stage_fully_differential_op_amp589
