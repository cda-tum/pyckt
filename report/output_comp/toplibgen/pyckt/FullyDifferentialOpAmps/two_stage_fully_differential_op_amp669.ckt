.suckt  two_stage_fully_differential_op_amp669 ibias in1 in2 out source_nmos source_pmos
M1 out1firststage in1 net_0 net_0 nmos
M2 out2firststage in2 net_0 net_0 nmos
M3 net_1 outfeedback source_pmos source_pmos pmos
M4 out1firststage bias_p_5 net_1 net_1 pmos
M5 net_3 outfeedback source_pmos source_pmos pmos
M6 out2firststage bias_p_5 net_3 net_3 pmos
M7 net_4 net_4 source_nmos source_nmos nmos
M8 net_0 net_5 net_4 net_4 nmos
M9 net_6 out2 net_7 net_7 nmos
M10 outfeedback vref net_7 net_7 nmos
M11 net_6 out1 net_8 net_8 nmos
M12 outfeedback vref net_8 net_8 nmos
M13 net_6 net_6 source_pmos source_pmos pmos
M14 outfeedback outfeedback source_pmos source_pmos pmos
M15 net_9 bias_n_4b source_nmos source_nmos nmos
M16 net_7 ibias net_9 net_9 nmos
M17 net_12 bias_n_4b source_nmos source_nmos nmos
M18 net_8 ibias net_12 net_12 nmos
M19 out1 out1firststage source_pmos source_pmos pmos
M20 net_13 net_13 source_nmos source_nmos nmos
M21 out1 net_14 net_13 net_13 nmos
M22 out2 out2firststage source_pmos source_pmos pmos
M23 net_15 net_15 source_nmos source_nmos nmos
M24 out2 net_16 net_15 net_15 nmos
M25 net_5 net_5 bias_n_1m bias_n_1m nmos
M26 bias_n_1m net_4 source_nmos source_nmos nmos
M27 net_14 net_14 bias_n_2m bias_n_2m nmos
M28 bias_n_2m net_13 source_nmos source_nmos nmos
M29 net_16 net_16 bias_n_3m bias_n_3m nmos
M30 bias_n_3m net_15 source_nmos source_nmos nmos
M31 bias_n_4b bias_n_4b source_nmos source_nmos nmos
M32 ibias ibias bias_n_4b bias_n_4b nmos
M33 bias_p_5 bias_p_5 source_pmos source_pmos pmos
M34 bias_p_6 bias_p_6 source_pmos source_pmos pmos
M35 bias_p_5 bias_n_4b source_nmos source_nmos nmos
M36 net_5 bias_p_6 source_pmos source_pmos pmos
M37 net_14 bias_p_6 source_pmos source_pmos pmos
M38 net_16 bias_p_6 source_pmos source_pmos pmos
M39 bias_p_6 bias_n_4b source_nmos source_nmos nmos
Cap_load_1 out1 source_nmos
Cap_load_2 out2 source_nmos
Cap_compensation_1 out1firststage out1
Cap_compensation_2 out2firststage out2
.end two_stage_fully_differential_op_amp669
