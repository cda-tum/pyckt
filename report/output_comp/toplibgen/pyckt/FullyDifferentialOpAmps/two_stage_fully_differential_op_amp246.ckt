.suckt  two_stage_fully_differential_op_amp246 ibias in1 in2 out source_nmos source_pmos
M1 net_0 in1 net_1 net_1 nmos
M2 net_2 in2 net_1 net_1 nmos
M3 out1firststage net_3 net_0 net_0 nmos
M4 out2firststage net_3 net_2 net_2 nmos
M5 out1firststage outfeedback source_pmos source_pmos pmos
M6 out2firststage outfeedback source_pmos source_pmos pmos
M7 net_1 bias_n_2 source_nmos source_nmos nmos
M8 net_5 out2 net_6 net_6 nmos
M9 outfeedback vref net_6 net_6 nmos
M10 net_5 out1 net_7 net_7 nmos
M11 outfeedback vref net_7 net_7 nmos
M12 net_5 net_5 source_pmos source_pmos pmos
M13 outfeedback outfeedback source_pmos source_pmos pmos
M14 net_6 bias_n_2 source_nmos source_nmos nmos
M15 net_7 bias_n_2 source_nmos source_nmos nmos
M16 net_9 net_9 source_pmos source_pmos pmos
M17 out1 net_10 net_9 net_9 pmos
M18 net_11 out1firststage source_nmos source_nmos nmos
M19 out1 bias_n_1 net_11 net_11 nmos
M20 net_13 net_13 source_pmos source_pmos pmos
M21 out2 ibias net_13 net_13 pmos
M22 net_15 out2firststage source_nmos source_nmos nmos
M23 out2 bias_n_1 net_15 net_15 nmos
M24 net_3 net_3 net_1 net_1 nmos
M25 bias_n_1 bias_n_1 source_nmos source_nmos nmos
M26 bias_n_2 bias_n_2 source_nmos source_nmos nmos
M27 net_10 net_10 bias_p_3m bias_p_3m pmos
M28 bias_p_3m net_9 source_pmos source_pmos pmos
M29 ibias ibias bias_p_4m bias_p_4m pmos
M30 bias_p_4m net_13 source_pmos source_pmos pmos
M31 bias_n_2 net_13 source_pmos source_pmos pmos
M32 net_3 net_13 source_pmos source_pmos pmos
M33 bias_n_1 net_13 source_pmos source_pmos pmos
M34 net_10 bias_n_2 source_nmos source_nmos nmos
Cap_load_1 out1 source_nmos
Cap_load_2 out2 source_nmos
Cap_compensation_1 out1firststage out1
Cap_compensation_2 out2firststage out2
.end two_stage_fully_differential_op_amp246
