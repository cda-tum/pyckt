.suckt  two_stage_fully_differential_op_amp89 ibias in1 in2 out source_nmos source_pmos
M1 net_0 in1 net_1 net_1 pmos
M2 net_2 in2 net_1 net_1 pmos
M3 net_0 outfeedback source_nmos source_nmos nmos
M4 out1firststage bias_n_1 net_0 net_0 nmos
M5 net_2 outfeedback source_nmos source_nmos nmos
M6 out2firststage bias_n_1 net_2 net_2 nmos
M7 net_4 ibias source_pmos source_pmos pmos
M8 out1firststage bias_p_4 net_4 net_4 pmos
M9 net_7 ibias source_pmos source_pmos pmos
M10 out2firststage bias_p_4 net_7 net_7 pmos
M11 net_1 ibias source_pmos source_pmos pmos
M12 net_9 out2 net_10 net_10 pmos
M13 outfeedback vref net_10 net_10 pmos
M14 net_9 out1 net_11 net_11 pmos
M15 outfeedback vref net_11 net_11 pmos
M16 net_9 net_9 source_nmos source_nmos nmos
M17 outfeedback outfeedback source_nmos source_nmos nmos
M18 net_12 ibias source_pmos source_pmos pmos
M19 net_10 bias_p_4 net_12 net_12 pmos
M20 net_15 ibias source_pmos source_pmos pmos
M21 net_11 bias_p_4 net_15 net_15 pmos
M22 net_16 net_16 source_pmos source_pmos pmos
M23 out1 net_17 net_16 net_16 pmos
M24 out1 out1firststage source_nmos source_nmos nmos
M25 net_18 net_18 source_pmos source_pmos pmos
M26 out2 net_19 net_18 net_18 pmos
M27 out2 out2firststage source_nmos source_nmos nmos
M28 bias_n_1 bias_n_1 source_nmos source_nmos nmos
M29 net_17 net_17 bias_p_2m bias_p_2m pmos
M30 bias_p_2m net_16 source_pmos source_pmos pmos
M31 net_19 net_19 bias_p_3m bias_p_3m pmos
M32 bias_p_3m net_18 source_pmos source_pmos pmos
M33 bias_p_4 bias_p_4 source_pmos source_pmos pmos
M34 ibias ibias source_pmos source_pmos pmos
M35 bias_n_6 bias_n_6 source_nmos source_nmos nmos
M36 bias_n_1 ibias source_pmos source_pmos pmos
M37 bias_p_4 bias_n_6 source_nmos source_nmos nmos
M38 net_17 bias_n_6 source_nmos source_nmos nmos
M39 net_19 bias_n_6 source_nmos source_nmos nmos
M40 bias_n_6 ibias source_pmos source_pmos pmos
Cap_load_1 out1 source_nmos
Cap_load_2 out2 source_nmos
Cap_compensation_1 out1firststage out1
Cap_compensation_2 out2firststage out2
.end two_stage_fully_differential_op_amp89
