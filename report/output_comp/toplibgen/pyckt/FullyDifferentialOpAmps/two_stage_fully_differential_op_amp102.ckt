.suckt  two_stage_fully_differential_op_amp102 ibias in1 in2 out source_nmos source_pmos
M1 net_0 in1 net_1 net_1 pmos
M2 net_2 in2 net_1 net_1 pmos
M3 out1firststage net_3 net_0 net_0 pmos
M4 out2firststage net_3 net_2 net_2 pmos
M5 out1firststage outfeedback source_nmos source_nmos nmos
M6 out2firststage outfeedback source_nmos source_nmos nmos
M7 net_1 ibias source_pmos source_pmos pmos
M8 net_5 out2 net_6 net_6 pmos
M9 outfeedback vref net_6 net_6 pmos
M10 net_5 out1 net_7 net_7 pmos
M11 outfeedback vref net_7 net_7 pmos
M12 net_5 net_5 source_nmos source_nmos nmos
M13 outfeedback outfeedback source_nmos source_nmos nmos
M14 net_6 ibias source_pmos source_pmos pmos
M15 net_7 ibias source_pmos source_pmos pmos
M16 net_9 net_9 source_pmos source_pmos pmos
M17 out1 net_10 net_9 net_9 pmos
M18 net_11 out1firststage source_nmos source_nmos nmos
M19 out1 bias_n_1 net_11 net_11 nmos
M20 net_13 net_13 source_pmos source_pmos pmos
M21 out2 net_14 net_13 net_13 pmos
M22 net_15 out2firststage source_nmos source_nmos nmos
M23 out2 bias_n_1 net_15 net_15 nmos
M24 bias_n_1 bias_n_1 source_nmos source_nmos nmos
M25 net_3 net_3 net_1 net_1 pmos
M26 net_10 net_10 bias_p_2m bias_p_2m pmos
M27 bias_p_2m net_9 source_pmos source_pmos pmos
M28 net_14 net_14 bias_p_3m bias_p_3m pmos
M29 bias_p_3m net_13 source_pmos source_pmos pmos
M30 ibias ibias source_pmos source_pmos pmos
M31 bias_n_5 bias_n_5 source_nmos source_nmos nmos
M32 bias_n_1 ibias source_pmos source_pmos pmos
M33 net_3 bias_n_5 source_nmos source_nmos nmos
M34 net_10 bias_n_5 source_nmos source_nmos nmos
M35 net_14 bias_n_5 source_nmos source_nmos nmos
M36 bias_n_5 ibias source_pmos source_pmos pmos
Cap_load_1 out1 source_nmos
Cap_load_2 out2 source_nmos
Cap_compensation_1 out1firststage out1
Cap_compensation_2 out2firststage out2
.end two_stage_fully_differential_op_amp102
