.suckt  two_stage_fully_differential_op_amp264 ibias in1 in2 out source_nmos source_pmos
M1 net_0 in1 net_1 net_1 nmos
M2 net_2 in2 net_1 net_1 nmos
M3 out1firststage net_3 net_0 net_0 nmos
M4 out2firststage net_3 net_2 net_2 nmos
M5 out1firststage outfeedback source_pmos source_pmos pmos
M6 out2firststage outfeedback source_pmos source_pmos pmos
M7 net_1 ibias source_nmos source_nmos nmos
M8 net_5 out2 net_6 net_6 nmos
M9 outfeedback vref net_6 net_6 nmos
M10 net_5 out1 net_7 net_7 nmos
M11 outfeedback vref net_7 net_7 nmos
M12 net_5 net_5 source_pmos source_pmos pmos
M13 outfeedback outfeedback source_pmos source_pmos pmos
M14 net_8 ibias source_nmos source_nmos nmos
M15 net_6 bias_n_3 net_8 net_8 nmos
M16 net_11 ibias source_nmos source_nmos nmos
M17 net_7 bias_n_3 net_11 net_11 nmos
M18 net_12 out1firststage source_pmos source_pmos pmos
M19 out1 bias_p_5 net_12 net_12 pmos
M20 net_14 net_14 source_nmos source_nmos nmos
M21 out1 net_15 net_14 net_14 nmos
M22 net_16 out2firststage source_pmos source_pmos pmos
M23 out2 bias_p_5 net_16 net_16 pmos
M24 net_18 net_18 source_nmos source_nmos nmos
M25 out2 net_19 net_18 net_18 nmos
M26 net_3 net_3 net_1 net_1 nmos
M27 net_15 net_15 bias_n_1m bias_n_1m nmos
M28 bias_n_1m net_14 source_nmos source_nmos nmos
M29 net_19 net_19 bias_n_2m bias_n_2m nmos
M30 bias_n_2m net_18 source_nmos source_nmos nmos
M31 bias_n_3 bias_n_3 source_nmos source_nmos nmos
M32 ibias ibias source_nmos source_nmos nmos
M33 bias_p_5 bias_p_5 source_pmos source_pmos pmos
M34 bias_p_6 bias_p_6 source_pmos source_pmos pmos
M35 net_3 bias_p_6 source_pmos source_pmos pmos
M36 bias_n_3 bias_p_6 source_pmos source_pmos pmos
M37 bias_p_5 ibias source_nmos source_nmos nmos
M38 net_15 bias_p_6 source_pmos source_pmos pmos
M39 net_19 bias_p_6 source_pmos source_pmos pmos
M40 bias_p_6 ibias source_nmos source_nmos nmos
Cap_load_1 out1 source_nmos
Cap_load_2 out2 source_nmos
Cap_compensation_1 out1firststage out1
Cap_compensation_2 out2firststage out2
.end two_stage_fully_differential_op_amp264
