.suckt  two_stage_fully_differential_op_amp97 ibias in1 in2 out source_nmos source_pmos
M1 net_0 in1 net_1 net_1 pmos
M2 net_2 in2 net_1 net_1 pmos
M3 out1firststage net_3 net_0 net_0 pmos
M4 out2firststage net_3 net_2 net_2 pmos
M5 out1firststage outfeedback source_nmos source_nmos nmos
M6 out2firststage outfeedback source_nmos source_nmos nmos
M7 net_1 ibias source_pmos source_pmos pmos
M8 net_5 out2 net_6 net_6 pmos
M9 outfeedback vref net_6 net_6 pmos
M10 net_5 out1 net_7 net_7 pmos
M11 outfeedback vref net_7 net_7 pmos
M12 net_5 net_5 source_nmos source_nmos nmos
M13 outfeedback outfeedback source_nmos source_nmos nmos
M14 net_6 ibias source_pmos source_pmos pmos
M15 net_7 ibias source_pmos source_pmos pmos
M16 out1 ibias source_pmos source_pmos pmos
M17 out1 out1firststage source_nmos source_nmos nmos
M18 out2 ibias source_pmos source_pmos pmos
M19 out2 out2firststage source_nmos source_nmos nmos
M20 net_3 net_3 net_1 net_1 pmos
M21 ibias ibias source_pmos source_pmos pmos
M22 bias_n_2 bias_n_2 source_nmos source_nmos nmos
M23 net_3 bias_n_2 source_nmos source_nmos nmos
M24 bias_n_2 ibias source_pmos source_pmos pmos
Cap_load_1 out1 source_nmos
Cap_load_2 out2 source_nmos
Cap_compensation_1 out1firststage out1
Cap_compensation_2 out2firststage out2
.end two_stage_fully_differential_op_amp97
