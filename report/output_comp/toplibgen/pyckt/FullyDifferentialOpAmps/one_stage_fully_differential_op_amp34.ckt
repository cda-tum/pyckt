.suckt  one_stage_fully_differential_op_amp34 ibias in1 in2 out source_nmos source_pmos
M1 net_0 in1 net_1 net_1 pmos
M2 net_2 in2 net_1 net_1 pmos
M3 net_0 outfeedback source_nmos source_nmos nmos
M4 out1 bias_n_1 net_0 net_0 nmos
M5 net_2 outfeedback source_nmos source_nmos nmos
M6 out2 bias_n_1 net_2 net_2 nmos
M7 out1 ibias source_pmos source_pmos pmos
M8 out2 ibias source_pmos source_pmos pmos
M9 net_5 ibias source_pmos source_pmos pmos
M10 net_1 bias_p_2 net_5 net_5 pmos
M11 net_8 out2 net_9 net_9 pmos
M12 outfeedback vref net_9 net_9 pmos
M13 net_8 out1 net_10 net_10 pmos
M14 outfeedback vref net_10 net_10 pmos
M15 net_8 net_8 source_nmos source_nmos nmos
M16 outfeedback outfeedback source_nmos source_nmos nmos
M17 net_11 ibias source_pmos source_pmos pmos
M18 net_9 bias_p_2 net_11 net_11 pmos
M19 net_14 ibias source_pmos source_pmos pmos
M20 net_10 bias_p_2 net_14 net_14 pmos
M21 bias_n_1 bias_n_1 source_nmos source_nmos nmos
M22 bias_p_2 bias_p_2 source_pmos source_pmos pmos
M23 ibias ibias source_pmos source_pmos pmos
M24 bias_n_4 bias_n_4 source_nmos source_nmos nmos
M25 bias_n_1 ibias source_pmos source_pmos pmos
M26 bias_p_2 bias_n_4 source_nmos source_nmos nmos
M27 bias_n_4 ibias source_pmos source_pmos pmos
Cap_load_1 out1 source_nmos
Cap_load_2 out2 source_nmos
.end one_stage_fully_differential_op_amp34
