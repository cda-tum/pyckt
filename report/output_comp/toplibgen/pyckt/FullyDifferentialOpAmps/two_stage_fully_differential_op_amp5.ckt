.suckt  two_stage_fully_differential_op_amp5 ibias in1 in2 out source_nmos source_pmos
M1 out1firststage in1 net_0 net_0 pmos
M2 out2firststage in2 net_0 net_0 pmos
M3 out1firststage outfeedback source_nmos source_nmos nmos
M4 out2firststage outfeedback source_nmos source_nmos nmos
M5 net_0 ibias source_pmos source_pmos pmos
M6 net_2 out2 net_3 net_3 pmos
M7 outfeedback vref net_3 net_3 pmos
M8 net_2 out1 net_4 net_4 pmos
M9 outfeedback vref net_4 net_4 pmos
M10 net_2 net_2 source_nmos source_nmos nmos
M11 outfeedback outfeedback source_nmos source_nmos nmos
M12 net_3 ibias source_pmos source_pmos pmos
M13 net_4 ibias source_pmos source_pmos pmos
M14 net_6 net_6 source_pmos source_pmos pmos
M15 out1 net_7 net_6 net_6 pmos
M16 out1 out1firststage source_nmos source_nmos nmos
M17 net_8 net_8 source_pmos source_pmos pmos
M18 out2 net_9 net_8 net_8 pmos
M19 out2 out2firststage source_nmos source_nmos nmos
M20 net_7 net_7 bias_p_1m bias_p_1m pmos
M21 bias_p_1m net_6 source_pmos source_pmos pmos
M22 net_9 net_9 bias_p_2m bias_p_2m pmos
M23 bias_p_2m net_8 source_pmos source_pmos pmos
M24 ibias ibias source_pmos source_pmos pmos
M25 bias_n_4 bias_n_4 source_nmos source_nmos nmos
M26 net_7 bias_n_4 source_nmos source_nmos nmos
M27 net_9 bias_n_4 source_nmos source_nmos nmos
M28 bias_n_4 ibias source_pmos source_pmos pmos
Cap_load_1 out1 source_nmos
Cap_load_2 out2 source_nmos
Cap_compensation_1 out1firststage out1
Cap_compensation_2 out2firststage out2
.end two_stage_fully_differential_op_amp5
