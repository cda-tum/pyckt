.suckt  two_stage_fully_differential_op_amp54 ibias in1 in2 out source_nmos source_pmos
M1 net_0 in1 net_1 net_1 pmos
M2 net_2 in2 net_1 net_1 pmos
M3 net_0 outfeedback source_nmos source_nmos nmos
M4 out1firststage bias_n_1 net_0 net_0 nmos
M5 net_2 outfeedback source_nmos source_nmos nmos
M6 out2firststage bias_n_1 net_2 net_2 nmos
M7 out1firststage ibias source_pmos source_pmos pmos
M8 out2firststage ibias source_pmos source_pmos pmos
M9 net_1 ibias source_pmos source_pmos pmos
M10 net_6 out2 net_7 net_7 pmos
M11 outfeedback vref net_7 net_7 pmos
M12 net_6 out1 net_8 net_8 pmos
M13 outfeedback vref net_8 net_8 pmos
M14 net_6 net_6 source_nmos source_nmos nmos
M15 outfeedback outfeedback source_nmos source_nmos nmos
M16 net_7 ibias source_pmos source_pmos pmos
M17 net_8 ibias source_pmos source_pmos pmos
M18 net_10 net_10 source_pmos source_pmos pmos
M19 out1 net_11 net_10 net_10 pmos
M20 net_12 out1firststage source_nmos source_nmos nmos
M21 out1 bias_n_1 net_12 net_12 nmos
M22 net_14 net_14 source_pmos source_pmos pmos
M23 out2 net_15 net_14 net_14 pmos
M24 net_16 out2firststage source_nmos source_nmos nmos
M25 out2 bias_n_1 net_16 net_16 nmos
M26 bias_n_1 bias_n_1 source_nmos source_nmos nmos
M27 net_11 net_11 bias_p_2m bias_p_2m pmos
M28 bias_p_2m net_10 source_pmos source_pmos pmos
M29 net_15 net_15 bias_p_3m bias_p_3m pmos
M30 bias_p_3m net_14 source_pmos source_pmos pmos
M31 ibias ibias source_pmos source_pmos pmos
M32 bias_n_5 bias_n_5 source_nmos source_nmos nmos
M33 bias_n_1 ibias source_pmos source_pmos pmos
M34 net_11 bias_n_5 source_nmos source_nmos nmos
M35 net_15 bias_n_5 source_nmos source_nmos nmos
M36 bias_n_5 ibias source_pmos source_pmos pmos
Cap_load_1 out1 source_nmos
Cap_load_2 out2 source_nmos
Cap_compensation_1 out1firststage out1
Cap_compensation_2 out2firststage out2
.end two_stage_fully_differential_op_amp54
