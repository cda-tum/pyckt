.suckt  one_stage_fully_differential_op_amp54 ibias in1 in2 out source_nmos source_pmos
M1 out1 in1 net_0 net_0 nmos
M2 out2 in2 net_0 net_0 nmos
M3 net_1 outfeedback source_pmos source_pmos pmos
M4 out1 bias_p_2 net_1 net_1 pmos
M5 net_3 outfeedback source_pmos source_pmos pmos
M6 out2 bias_p_2 net_3 net_3 pmos
M7 net_4 bias_n_1b source_nmos source_nmos nmos
M8 net_0 ibias net_4 net_4 nmos
M9 net_7 out2 net_8 net_8 nmos
M10 outfeedback vref net_8 net_8 nmos
M11 net_7 out1 net_9 net_9 nmos
M12 outfeedback vref net_9 net_9 nmos
M13 net_7 net_7 source_pmos source_pmos pmos
M14 outfeedback outfeedback source_pmos source_pmos pmos
M15 net_10 bias_n_1b source_nmos source_nmos nmos
M16 net_8 ibias net_10 net_10 nmos
M17 net_13 bias_n_1b source_nmos source_nmos nmos
M18 net_9 ibias net_13 net_13 nmos
M19 bias_n_1b bias_n_1b source_nmos source_nmos nmos
M20 ibias ibias bias_n_1b bias_n_1b nmos
M21 bias_p_2 bias_p_2 source_pmos source_pmos pmos
M22 bias_p_2 bias_n_1b source_nmos source_nmos nmos
Cap_load_1 out1 source_nmos
Cap_load_2 out2 source_nmos
.end one_stage_fully_differential_op_amp54
