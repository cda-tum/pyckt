.suckt  two_stage_fully_differential_op_amp55 ibias in1 in2 out source_nmos source_pmos
M1 net_0 in1 net_1 net_1 pmos
M2 net_2 in2 net_1 net_1 pmos
M3 net_0 outfeedback source_nmos source_nmos nmos
M4 out1firststage bias_n_1 net_0 net_0 nmos
M5 net_2 outfeedback source_nmos source_nmos nmos
M6 out2firststage bias_n_1 net_2 net_2 nmos
M7 out1firststage ibias source_pmos source_pmos pmos
M8 out2firststage ibias source_pmos source_pmos pmos
M9 net_1 ibias source_pmos source_pmos pmos
M10 net_6 out2 net_7 net_7 pmos
M11 outfeedback vref net_7 net_7 pmos
M12 net_6 out1 net_8 net_8 pmos
M13 outfeedback vref net_8 net_8 pmos
M14 net_6 net_6 source_nmos source_nmos nmos
M15 outfeedback outfeedback source_nmos source_nmos nmos
M16 net_7 ibias source_pmos source_pmos pmos
M17 net_8 ibias source_pmos source_pmos pmos
M18 out1 out1firststage source_pmos source_pmos pmos
M19 out1 bias_n_2 source_nmos source_nmos nmos
M20 out2 out2firststage source_pmos source_pmos pmos
M21 out2 bias_n_2 source_nmos source_nmos nmos
M22 bias_n_1 bias_n_1 source_nmos source_nmos nmos
M23 bias_n_2 bias_n_2 source_nmos source_nmos nmos
M24 ibias ibias source_pmos source_pmos pmos
M25 bias_n_2 ibias source_pmos source_pmos pmos
M26 bias_n_1 ibias source_pmos source_pmos pmos
Cap_load_1 out1 source_nmos
Cap_load_2 out2 source_nmos
Cap_compensation_1 out1firststage out1
Cap_compensation_2 out2firststage out2
.end two_stage_fully_differential_op_amp55
