.suckt  one_stage_fully_differential_op_amp60 ibias in1 in2 out source_nmos source_pmos
M1 net_0 in1 net_1 net_1 nmos
M2 net_2 in2 net_1 net_1 nmos
M3 net_0 outfeedback source_pmos source_pmos pmos
M4 out1 bias_p_4 net_0 net_0 pmos
M5 net_2 outfeedback source_pmos source_pmos pmos
M6 out2 bias_p_4 net_2 net_2 pmos
M7 out1 ibias source_nmos source_nmos nmos
M8 out2 ibias source_nmos source_nmos nmos
M9 net_5 net_5 source_nmos source_nmos nmos
M10 net_1 net_6 net_5 net_5 nmos
M11 net_7 out2 net_8 net_8 nmos
M12 outfeedback vref net_8 net_8 nmos
M13 net_7 out1 net_9 net_9 nmos
M14 outfeedback vref net_9 net_9 nmos
M15 net_7 net_7 source_pmos source_pmos pmos
M16 outfeedback outfeedback source_pmos source_pmos pmos
M17 net_10 ibias source_nmos source_nmos nmos
M18 net_8 bias_n_2 net_10 net_10 nmos
M19 net_13 ibias source_nmos source_nmos nmos
M20 net_9 bias_n_2 net_13 net_13 nmos
M21 net_6 net_6 bias_n_1m bias_n_1m nmos
M22 bias_n_1m net_5 source_nmos source_nmos nmos
M23 bias_n_2 bias_n_2 source_nmos source_nmos nmos
M24 ibias ibias source_nmos source_nmos nmos
M25 bias_p_4 bias_p_4 source_pmos source_pmos pmos
M26 bias_p_5 bias_p_5 source_pmos source_pmos pmos
M27 bias_n_2 bias_p_5 source_pmos source_pmos pmos
M28 bias_p_4 ibias source_nmos source_nmos nmos
M29 net_6 bias_p_5 source_pmos source_pmos pmos
M30 bias_p_5 ibias source_nmos source_nmos nmos
Cap_load_1 out1 source_nmos
Cap_load_2 out2 source_nmos
.end one_stage_fully_differential_op_amp60
