.suckt  two_stage_fully_differential_op_amp210 ibias in1 in2 out source_nmos source_pmos
M1 net_0 in1 net_1 net_1 nmos
M2 net_2 in2 net_1 net_1 nmos
M3 net_0 outfeedback source_pmos source_pmos pmos
M4 out1firststage bias_p_5 net_0 net_0 pmos
M5 net_2 outfeedback source_pmos source_pmos pmos
M6 out2firststage bias_p_5 net_2 net_2 pmos
M7 out1firststage ibias source_nmos source_nmos nmos
M8 out2firststage ibias source_nmos source_nmos nmos
M9 net_1 ibias source_nmos source_nmos nmos
M10 net_6 out2 net_7 net_7 nmos
M11 outfeedback vref net_7 net_7 nmos
M12 net_6 out1 net_8 net_8 nmos
M13 outfeedback vref net_8 net_8 nmos
M14 net_6 net_6 source_pmos source_pmos pmos
M15 outfeedback outfeedback source_pmos source_pmos pmos
M16 net_9 ibias source_nmos source_nmos nmos
M17 net_7 bias_n_1 net_9 net_9 nmos
M18 net_12 ibias source_nmos source_nmos nmos
M19 net_8 bias_n_1 net_12 net_12 nmos
M20 net_13 net_13 source_pmos source_pmos pmos
M21 out1 net_14 net_13 net_13 pmos
M22 net_15 out1firststage source_nmos source_nmos nmos
M23 out1 bias_n_1 net_15 net_15 nmos
M24 net_17 net_17 source_pmos source_pmos pmos
M25 out2 net_18 net_17 net_17 pmos
M26 net_19 out2firststage source_nmos source_nmos nmos
M27 out2 bias_n_1 net_19 net_19 nmos
M28 bias_n_1 bias_n_1 source_nmos source_nmos nmos
M29 ibias ibias source_nmos source_nmos nmos
M30 net_14 net_14 bias_p_3m bias_p_3m pmos
M31 bias_p_3m net_13 source_pmos source_pmos pmos
M32 net_18 net_18 bias_p_4m bias_p_4m pmos
M33 bias_p_4m net_17 source_pmos source_pmos pmos
M34 bias_p_5 bias_p_5 source_pmos source_pmos pmos
M35 bias_p_6 bias_p_6 source_pmos source_pmos pmos
M36 net_18 ibias source_nmos source_nmos nmos
M37 bias_n_1 bias_p_6 source_pmos source_pmos pmos
M38 bias_p_5 ibias source_nmos source_nmos nmos
M39 net_14 ibias source_nmos source_nmos nmos
M40 bias_p_6 ibias source_nmos source_nmos nmos
Cap_load_1 out1 source_nmos
Cap_load_2 out2 source_nmos
Cap_compensation_1 out1firststage out1
Cap_compensation_2 out2firststage out2
.end two_stage_fully_differential_op_amp210
