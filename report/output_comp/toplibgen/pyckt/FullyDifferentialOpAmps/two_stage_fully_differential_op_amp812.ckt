.suckt  two_stage_fully_differential_op_amp812 ibias in1 in2 out source_nmos source_pmos
M1 net_0 in1 net_1 net_1 nmos
M2 net_2 in2 net_1 net_1 nmos
M3 out1firststage net_3 net_0 net_0 nmos
M4 out2firststage net_3 net_2 net_2 nmos
M5 out1firststage outfeedback source_pmos source_pmos pmos
M6 out2firststage outfeedback source_pmos source_pmos pmos
M7 net_4 net_4 source_nmos source_nmos nmos
M8 net_1 net_5 net_4 net_4 nmos
M9 net_6 out2 net_7 net_7 nmos
M10 outfeedback vref net_7 net_7 nmos
M11 net_6 out1 net_8 net_8 nmos
M12 outfeedback vref net_8 net_8 nmos
M13 net_6 net_6 source_pmos source_pmos pmos
M14 outfeedback outfeedback source_pmos source_pmos pmos
M15 net_9 bias_n_2b source_nmos source_nmos nmos
M16 net_7 ibias net_9 net_9 nmos
M17 net_12 bias_n_2b source_nmos source_nmos nmos
M18 net_8 ibias net_12 net_12 nmos
M19 out1 out1firststage source_pmos source_pmos pmos
M20 net_13 bias_n_2b source_nmos source_nmos nmos
M21 out1 ibias net_13 net_13 nmos
M22 out2 out2firststage source_pmos source_pmos pmos
M23 net_16 bias_n_2b source_nmos source_nmos nmos
M24 out2 ibias net_16 net_16 nmos
M25 net_3 net_3 net_1 net_1 nmos
M26 net_5 net_5 bias_n_1m bias_n_1m nmos
M27 bias_n_1m net_4 source_nmos source_nmos nmos
M28 bias_n_2b bias_n_2b source_nmos source_nmos nmos
M29 ibias ibias bias_n_2b bias_n_2b nmos
M30 bias_p_3 bias_p_3 source_pmos source_pmos pmos
M31 net_3 bias_p_3 source_pmos source_pmos pmos
M32 net_5 bias_p_3 source_pmos source_pmos pmos
M33 bias_p_3 bias_n_2b source_nmos source_nmos nmos
Cap_load_1 out1 source_nmos
Cap_load_2 out2 source_nmos
Cap_compensation_1 out1firststage out1
Cap_compensation_2 out2firststage out2
.end two_stage_fully_differential_op_amp812
