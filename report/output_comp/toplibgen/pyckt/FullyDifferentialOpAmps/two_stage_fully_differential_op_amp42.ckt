.suckt  two_stage_fully_differential_op_amp42 ibias in1 in2 out source_nmos source_pmos
M1 out1firststage in1 net_0 net_0 pmos
M2 out2firststage in2 net_0 net_0 pmos
M3 net_1 outfeedback source_nmos source_nmos nmos
M4 out1firststage bias_n_1 net_1 net_1 nmos
M5 net_3 outfeedback source_nmos source_nmos nmos
M6 out2firststage bias_n_1 net_3 net_3 nmos
M7 net_0 ibias source_pmos source_pmos pmos
M8 net_5 out2 net_6 net_6 pmos
M9 outfeedback vref net_6 net_6 pmos
M10 net_5 out1 net_7 net_7 pmos
M11 outfeedback vref net_7 net_7 pmos
M12 net_5 net_5 source_nmos source_nmos nmos
M13 outfeedback outfeedback source_nmos source_nmos nmos
M14 net_8 ibias source_pmos source_pmos pmos
M15 net_6 bias_p_4 net_8 net_8 pmos
M16 net_11 ibias source_pmos source_pmos pmos
M17 net_7 bias_p_4 net_11 net_11 pmos
M18 net_12 net_12 source_pmos source_pmos pmos
M19 out1 net_13 net_12 net_12 pmos
M20 net_14 out1firststage source_nmos source_nmos nmos
M21 out1 bias_n_1 net_14 net_14 nmos
M22 net_16 net_16 source_pmos source_pmos pmos
M23 out2 net_17 net_16 net_16 pmos
M24 net_18 out2firststage source_nmos source_nmos nmos
M25 out2 bias_n_1 net_18 net_18 nmos
M26 bias_n_1 bias_n_1 source_nmos source_nmos nmos
M27 net_13 net_13 bias_p_2m bias_p_2m pmos
M28 bias_p_2m net_12 source_pmos source_pmos pmos
M29 net_17 net_17 bias_p_3m bias_p_3m pmos
M30 bias_p_3m net_16 source_pmos source_pmos pmos
M31 bias_p_4 bias_p_4 source_pmos source_pmos pmos
M32 ibias ibias source_pmos source_pmos pmos
M33 bias_n_6 bias_n_6 source_nmos source_nmos nmos
M34 bias_n_1 ibias source_pmos source_pmos pmos
M35 bias_p_4 bias_n_6 source_nmos source_nmos nmos
M36 net_13 bias_n_6 source_nmos source_nmos nmos
M37 net_17 bias_n_6 source_nmos source_nmos nmos
M38 bias_n_6 ibias source_pmos source_pmos pmos
Cap_load_1 out1 source_nmos
Cap_load_2 out2 source_nmos
Cap_compensation_1 out1firststage out1
Cap_compensation_2 out2firststage out2
.end two_stage_fully_differential_op_amp42
