.suckt  one_stage_fully_differential_op_amp49 ibias in1 in2 out source_nmos source_pmos
M1 out1 in1 net_0 net_0 nmos
M2 out2 in2 net_0 net_0 nmos
M3 out1 outfeedback source_pmos source_pmos pmos
M4 out2 outfeedback source_pmos source_pmos pmos
M5 net_1 ibias source_nmos source_nmos nmos
M6 net_0 bias_n_1 net_1 net_1 nmos
M7 net_4 out2 net_5 net_5 nmos
M8 outfeedback vref net_5 net_5 nmos
M9 net_4 out1 net_6 net_6 nmos
M10 outfeedback vref net_6 net_6 nmos
M11 net_4 net_4 source_pmos source_pmos pmos
M12 outfeedback outfeedback source_pmos source_pmos pmos
M13 net_5 ibias source_nmos source_nmos nmos
M14 net_6 ibias source_nmos source_nmos nmos
M15 bias_n_1 bias_n_1 source_nmos source_nmos nmos
M16 ibias ibias source_nmos source_nmos nmos
M17 bias_p_3 bias_p_3 source_pmos source_pmos pmos
M18 bias_n_1 bias_p_3 source_pmos source_pmos pmos
M19 bias_p_3 ibias source_nmos source_nmos nmos
Cap_load_1 out1 source_nmos
Cap_load_2 out2 source_nmos
.end one_stage_fully_differential_op_amp49
