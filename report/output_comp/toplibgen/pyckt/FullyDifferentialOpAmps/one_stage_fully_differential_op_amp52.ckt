.suckt  one_stage_fully_differential_op_amp52 ibias in1 in2 out source_nmos source_pmos
M1 out1 in1 net_0 net_0 nmos
M2 out2 in2 net_0 net_0 nmos
M3 out1 outfeedback source_pmos source_pmos pmos
M4 out2 outfeedback source_pmos source_pmos pmos
M5 net_1 net_1 source_nmos source_nmos nmos
M6 net_0 net_2 net_1 net_1 nmos
M7 net_3 out2 net_4 net_4 nmos
M8 outfeedback vref net_4 net_4 nmos
M9 net_3 out1 net_5 net_5 nmos
M10 outfeedback vref net_5 net_5 nmos
M11 net_3 net_3 source_pmos source_pmos pmos
M12 outfeedback outfeedback source_pmos source_pmos pmos
M13 net_6 bias_n_2b source_nmos source_nmos nmos
M14 net_4 ibias net_6 net_6 nmos
M15 net_9 bias_n_2b source_nmos source_nmos nmos
M16 net_5 ibias net_9 net_9 nmos
M17 net_2 net_2 bias_n_1m bias_n_1m nmos
M18 bias_n_1m net_1 source_nmos source_nmos nmos
M19 bias_n_2b bias_n_2b source_nmos source_nmos nmos
M20 ibias ibias bias_n_2b bias_n_2b nmos
M21 bias_p_3 bias_p_3 source_pmos source_pmos pmos
M22 net_2 bias_p_3 source_pmos source_pmos pmos
M23 bias_p_3 bias_n_2b source_nmos source_nmos nmos
Cap_load_1 out1 source_nmos
Cap_load_2 out2 source_nmos
.end one_stage_fully_differential_op_amp52
