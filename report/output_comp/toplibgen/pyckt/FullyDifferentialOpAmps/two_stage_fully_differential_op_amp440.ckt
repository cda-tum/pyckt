.suckt  two_stage_fully_differential_op_amp440 ibias in1 in2 out source_nmos source_pmos
M1 net_0 in1 net_1 net_1 pmos
M2 net_2 in2 net_1 net_1 pmos
M3 net_0 outfeedback source_nmos source_nmos nmos
M4 out1firststage bias_n_1 net_0 net_0 nmos
M5 net_2 outfeedback source_nmos source_nmos nmos
M6 out2firststage bias_n_1 net_2 net_2 nmos
M7 net_4 ibias source_pmos source_pmos pmos
M8 out1firststage bias_p_3 net_4 net_4 pmos
M9 net_7 ibias source_pmos source_pmos pmos
M10 out2firststage bias_p_3 net_7 net_7 pmos
M11 net_8 ibias source_pmos source_pmos pmos
M12 net_1 bias_p_3 net_8 net_8 pmos
M13 net_11 out2 net_12 net_12 pmos
M14 outfeedback vref net_12 net_12 pmos
M15 net_11 out1 net_13 net_13 pmos
M16 outfeedback vref net_13 net_13 pmos
M17 net_11 net_11 source_nmos source_nmos nmos
M18 outfeedback outfeedback source_nmos source_nmos nmos
M19 net_12 ibias source_pmos source_pmos pmos
M20 net_13 ibias source_pmos source_pmos pmos
M21 out1 out1firststage source_pmos source_pmos pmos
M22 net_15 bias_n_2 source_nmos source_nmos nmos
M23 out1 bias_n_1 net_15 net_15 nmos
M24 out2 out2firststage source_pmos source_pmos pmos
M25 net_18 bias_n_2 source_nmos source_nmos nmos
M26 out2 bias_n_1 net_18 net_18 nmos
M27 bias_n_1 bias_n_1 source_nmos source_nmos nmos
M28 bias_n_2 bias_n_2 source_nmos source_nmos nmos
M29 bias_p_3 bias_p_3 source_pmos source_pmos pmos
M30 ibias ibias source_pmos source_pmos pmos
M31 bias_n_2 ibias source_pmos source_pmos pmos
M32 bias_n_1 ibias source_pmos source_pmos pmos
M33 bias_p_3 bias_n_2 source_nmos source_nmos nmos
Cap_load_1 out1 source_nmos
Cap_load_2 out2 source_nmos
Cap_compensation_1 out1firststage out1
Cap_compensation_2 out2firststage out2
.end two_stage_fully_differential_op_amp440
