.suckt  two_stage_fully_differential_op_amp656 ibias in1 in2 out source_nmos source_pmos
M1 out1firststage in1 net_0 net_0 nmos
M2 out2firststage in2 net_0 net_0 nmos
M3 net_1 outfeedback source_pmos source_pmos pmos
M4 out1firststage bias_p_4 net_1 net_1 pmos
M5 net_3 outfeedback source_pmos source_pmos pmos
M6 out2firststage bias_p_4 net_3 net_3 pmos
M7 net_4 net_4 source_nmos source_nmos nmos
M8 net_0 net_5 net_4 net_4 nmos
M9 net_6 out2 net_7 net_7 nmos
M10 outfeedback vref net_7 net_7 nmos
M11 net_6 out1 net_8 net_8 nmos
M12 outfeedback vref net_8 net_8 nmos
M13 net_6 net_6 source_pmos source_pmos pmos
M14 outfeedback outfeedback source_pmos source_pmos pmos
M15 net_7 ibias source_nmos source_nmos nmos
M16 net_8 ibias source_nmos source_nmos nmos
M17 out1 out1firststage source_pmos source_pmos pmos
M18 net_10 ibias source_nmos source_nmos nmos
M19 out1 bias_n_2 net_10 net_10 nmos
M20 out2 out2firststage source_pmos source_pmos pmos
M21 net_13 ibias source_nmos source_nmos nmos
M22 out2 bias_n_2 net_13 net_13 nmos
M23 net_5 net_5 bias_n_1m bias_n_1m nmos
M24 bias_n_1m net_4 source_nmos source_nmos nmos
M25 bias_n_2 bias_n_2 source_nmos source_nmos nmos
M26 ibias ibias source_nmos source_nmos nmos
M27 bias_p_4 bias_p_4 source_pmos source_pmos pmos
M28 bias_p_5 bias_p_5 source_pmos source_pmos pmos
M29 bias_n_2 bias_p_5 source_pmos source_pmos pmos
M30 bias_p_4 ibias source_nmos source_nmos nmos
M31 net_5 bias_p_5 source_pmos source_pmos pmos
M32 bias_p_5 ibias source_nmos source_nmos nmos
Cap_load_1 out1 source_nmos
Cap_load_2 out2 source_nmos
Cap_compensation_1 out1firststage out1
Cap_compensation_2 out2firststage out2
.end two_stage_fully_differential_op_amp656
