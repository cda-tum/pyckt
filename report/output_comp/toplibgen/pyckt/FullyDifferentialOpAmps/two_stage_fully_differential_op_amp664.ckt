.suckt  two_stage_fully_differential_op_amp664 ibias in1 in2 out source_nmos source_pmos
M1 out1firststage in1 net_0 net_0 nmos
M2 out2firststage in2 net_0 net_0 nmos
M3 net_1 outfeedback source_pmos source_pmos pmos
M4 out1firststage bias_p_4 net_1 net_1 pmos
M5 net_3 outfeedback source_pmos source_pmos pmos
M6 out2firststage bias_p_4 net_3 net_3 pmos
M7 net_4 net_4 source_nmos source_nmos nmos
M8 net_0 net_5 net_4 net_4 nmos
M9 net_6 out2 net_7 net_7 nmos
M10 outfeedback vref net_7 net_7 nmos
M11 net_6 out1 net_8 net_8 nmos
M12 outfeedback vref net_8 net_8 nmos
M13 net_6 net_6 source_pmos source_pmos pmos
M14 outfeedback outfeedback source_pmos source_pmos pmos
M15 net_9 bias_n_3 source_nmos source_nmos nmos
M16 net_7 bias_n_2 net_9 net_9 nmos
M17 net_12 bias_n_3 source_nmos source_nmos nmos
M18 net_8 bias_n_2 net_12 net_12 nmos
M19 net_13 ibias source_pmos source_pmos pmos
M20 out1 bias_p_4 net_13 net_13 pmos
M21 net_16 out1firststage source_nmos source_nmos nmos
M22 out1 bias_n_2 net_16 net_16 nmos
M23 net_18 ibias source_pmos source_pmos pmos
M24 out2 bias_p_4 net_18 net_18 pmos
M25 net_21 out2firststage source_nmos source_nmos nmos
M26 out2 bias_n_2 net_21 net_21 nmos
M27 net_5 net_5 bias_n_1m bias_n_1m nmos
M28 bias_n_1m net_4 source_nmos source_nmos nmos
M29 bias_n_2 bias_n_2 source_nmos source_nmos nmos
M30 bias_n_3 bias_n_3 source_nmos source_nmos nmos
M31 bias_p_4 bias_p_4 source_pmos source_pmos pmos
M32 ibias ibias source_pmos source_pmos pmos
M33 bias_n_3 ibias source_pmos source_pmos pmos
M34 bias_n_2 ibias source_pmos source_pmos pmos
M35 bias_p_4 bias_n_3 source_nmos source_nmos nmos
M36 net_5 ibias source_pmos source_pmos pmos
Cap_load_1 out1 source_nmos
Cap_load_2 out2 source_nmos
Cap_compensation_1 out1firststage out1
Cap_compensation_2 out2firststage out2
.end two_stage_fully_differential_op_amp664
