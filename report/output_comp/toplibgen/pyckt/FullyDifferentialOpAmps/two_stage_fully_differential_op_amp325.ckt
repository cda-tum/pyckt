.suckt  two_stage_fully_differential_op_amp325 ibias in1 in2 out source_nmos source_pmos
M1 out1firststage in1 net_0 net_0 pmos
M2 out2firststage in2 net_0 net_0 pmos
M3 out1firststage outfeedback source_nmos source_nmos nmos
M4 out2firststage outfeedback source_nmos source_nmos nmos
M5 net_1 net_1 source_pmos source_pmos pmos
M6 net_0 net_2 net_1 net_1 pmos
M7 net_3 out2 net_4 net_4 pmos
M8 outfeedback vref net_4 net_4 pmos
M9 net_3 out1 net_5 net_5 pmos
M10 outfeedback vref net_5 net_5 pmos
M11 net_3 net_3 source_nmos source_nmos nmos
M12 outfeedback outfeedback source_nmos source_nmos nmos
M13 net_6 ibias source_pmos source_pmos pmos
M14 net_4 bias_p_2 net_6 net_6 pmos
M15 net_9 ibias source_pmos source_pmos pmos
M16 net_5 bias_p_2 net_9 net_9 pmos
M17 out1 ibias source_pmos source_pmos pmos
M18 out1 out1firststage source_nmos source_nmos nmos
M19 out2 ibias source_pmos source_pmos pmos
M20 out2 out2firststage source_nmos source_nmos nmos
M21 net_2 net_2 bias_p_1m bias_p_1m pmos
M22 bias_p_1m net_1 source_pmos source_pmos pmos
M23 bias_p_2 bias_p_2 source_pmos source_pmos pmos
M24 ibias ibias source_pmos source_pmos pmos
M25 bias_n_4 bias_n_4 source_nmos source_nmos nmos
M26 bias_p_2 bias_n_4 source_nmos source_nmos nmos
M27 net_2 bias_n_4 source_nmos source_nmos nmos
M28 bias_n_4 ibias source_pmos source_pmos pmos
Cap_load_1 out1 source_nmos
Cap_load_2 out2 source_nmos
Cap_compensation_1 out1firststage out1
Cap_compensation_2 out2firststage out2
.end two_stage_fully_differential_op_amp325
