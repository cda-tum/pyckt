.suckt  one_stage_fully_differential_op_amp56 ibias in1 in2 out source_nmos source_pmos
M1 out1 in1 net_0 net_0 nmos
M2 out2 in2 net_0 net_0 nmos
M3 net_1 outfeedback source_pmos source_pmos pmos
M4 out1 bias_p_3 net_1 net_1 pmos
M5 net_3 outfeedback source_pmos source_pmos pmos
M6 out2 bias_p_3 net_3 net_3 pmos
M7 net_4 net_4 source_nmos source_nmos nmos
M8 net_0 net_5 net_4 net_4 nmos
M9 net_6 out2 net_7 net_7 nmos
M10 outfeedback vref net_7 net_7 nmos
M11 net_6 out1 net_8 net_8 nmos
M12 outfeedback vref net_8 net_8 nmos
M13 net_6 net_6 source_pmos source_pmos pmos
M14 outfeedback outfeedback source_pmos source_pmos pmos
M15 net_9 bias_n_2b source_nmos source_nmos nmos
M16 net_7 ibias net_9 net_9 nmos
M17 net_12 bias_n_2b source_nmos source_nmos nmos
M18 net_8 ibias net_12 net_12 nmos
M19 net_5 net_5 bias_n_1m bias_n_1m nmos
M20 bias_n_1m net_4 source_nmos source_nmos nmos
M21 bias_n_2b bias_n_2b source_nmos source_nmos nmos
M22 ibias ibias bias_n_2b bias_n_2b nmos
M23 bias_p_3 bias_p_3 source_pmos source_pmos pmos
M24 bias_p_4 bias_p_4 source_pmos source_pmos pmos
M25 bias_p_3 bias_n_2b source_nmos source_nmos nmos
M26 net_5 bias_p_4 source_pmos source_pmos pmos
M27 bias_p_4 bias_n_2b source_nmos source_nmos nmos
Cap_load_1 out1 source_nmos
Cap_load_2 out2 source_nmos
.end one_stage_fully_differential_op_amp56
