.suckt  two_stage_fully_differential_op_amp110 ibias in1 in2 out source_nmos source_pmos
M1 net_0 in1 net_1 net_1 pmos
M2 net_2 in2 net_1 net_1 pmos
M3 out1firststage net_3 net_0 net_0 pmos
M4 out2firststage net_3 net_2 net_2 pmos
M5 out1firststage outfeedback source_nmos source_nmos nmos
M6 out2firststage outfeedback source_nmos source_nmos nmos
M7 net_1 ibias source_pmos source_pmos pmos
M8 net_5 out2 net_6 net_6 pmos
M9 outfeedback vref net_6 net_6 pmos
M10 net_5 out1 net_7 net_7 pmos
M11 outfeedback vref net_7 net_7 pmos
M12 net_5 net_5 source_nmos source_nmos nmos
M13 outfeedback outfeedback source_nmos source_nmos nmos
M14 net_8 ibias source_pmos source_pmos pmos
M15 net_6 bias_p_2 net_8 net_8 pmos
M16 net_11 ibias source_pmos source_pmos pmos
M17 net_7 bias_p_2 net_11 net_11 pmos
M18 out1 ibias source_pmos source_pmos pmos
M19 net_13 out1firststage source_nmos source_nmos nmos
M20 out1 bias_n_1 net_13 net_13 nmos
M21 out2 ibias source_pmos source_pmos pmos
M22 net_16 out2firststage source_nmos source_nmos nmos
M23 out2 bias_n_1 net_16 net_16 nmos
M24 bias_n_1 bias_n_1 source_nmos source_nmos nmos
M25 net_3 net_3 net_1 net_1 pmos
M26 bias_p_2 bias_p_2 source_pmos source_pmos pmos
M27 ibias ibias source_pmos source_pmos pmos
M28 bias_n_4 bias_n_4 source_nmos source_nmos nmos
M29 bias_n_1 ibias source_pmos source_pmos pmos
M30 net_3 bias_n_4 source_nmos source_nmos nmos
M31 bias_p_2 bias_n_4 source_nmos source_nmos nmos
M32 bias_n_4 ibias source_pmos source_pmos pmos
Cap_load_1 out1 source_nmos
Cap_load_2 out2 source_nmos
Cap_compensation_1 out1firststage out1
Cap_compensation_2 out2firststage out2
.end two_stage_fully_differential_op_amp110
