.suckt  two_stage_fully_differential_op_amp125 ibias in1 in2 out source_nmos source_pmos
M1 net_0 in1 net_1 net_1 pmos
M2 net_2 in2 net_1 net_1 pmos
M3 out1firststage net_3 net_0 net_0 pmos
M4 out2firststage net_3 net_2 net_2 pmos
M5 net_4 outfeedback source_nmos source_nmos nmos
M6 out1firststage bias_n_1 net_4 net_4 nmos
M7 net_6 outfeedback source_nmos source_nmos nmos
M8 out2firststage bias_n_1 net_6 net_6 nmos
M9 net_1 ibias source_pmos source_pmos pmos
M10 net_8 out2 net_9 net_9 pmos
M11 outfeedback vref net_9 net_9 pmos
M12 net_8 out1 net_10 net_10 pmos
M13 outfeedback vref net_10 net_10 pmos
M14 net_8 net_8 source_nmos source_nmos nmos
M15 outfeedback outfeedback source_nmos source_nmos nmos
M16 net_9 ibias source_pmos source_pmos pmos
M17 net_10 ibias source_pmos source_pmos pmos
M18 net_12 net_12 source_pmos source_pmos pmos
M19 out1 net_13 net_12 net_12 pmos
M20 out1 out1firststage source_nmos source_nmos nmos
M21 net_14 net_14 source_pmos source_pmos pmos
M22 out2 net_15 net_14 net_14 pmos
M23 out2 out2firststage source_nmos source_nmos nmos
M24 bias_n_1 bias_n_1 source_nmos source_nmos nmos
M25 net_3 net_3 net_1 net_1 pmos
M26 net_13 net_13 bias_p_2m bias_p_2m pmos
M27 bias_p_2m net_12 source_pmos source_pmos pmos
M28 net_15 net_15 bias_p_3m bias_p_3m pmos
M29 bias_p_3m net_14 source_pmos source_pmos pmos
M30 ibias ibias source_pmos source_pmos pmos
M31 bias_n_5 bias_n_5 source_nmos source_nmos nmos
M32 bias_n_1 ibias source_pmos source_pmos pmos
M33 net_3 bias_n_5 source_nmos source_nmos nmos
M34 net_13 bias_n_5 source_nmos source_nmos nmos
M35 net_15 bias_n_5 source_nmos source_nmos nmos
M36 bias_n_5 ibias source_pmos source_pmos pmos
Cap_load_1 out1 source_nmos
Cap_load_2 out2 source_nmos
Cap_compensation_1 out1firststage out1
Cap_compensation_2 out2firststage out2
.end two_stage_fully_differential_op_amp125
