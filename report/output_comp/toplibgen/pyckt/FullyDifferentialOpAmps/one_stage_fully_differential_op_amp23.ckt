.suckt  one_stage_fully_differential_op_amp23 ibias in1 in2 out source_nmos source_pmos
M1 net_0 in1 net_1 net_1 nmos
M2 net_2 in2 net_1 net_1 nmos
M3 out1 net_3 net_0 net_0 nmos
M4 out2 net_3 net_2 net_2 nmos
M5 net_4 outfeedback source_pmos source_pmos pmos
M6 out1 bias_p_2 net_4 net_4 pmos
M7 net_6 outfeedback source_pmos source_pmos pmos
M8 out2 bias_p_2 net_6 net_6 pmos
M9 net_1 ibias source_nmos source_nmos nmos
M10 net_8 out2 net_9 net_9 nmos
M11 outfeedback vref net_9 net_9 nmos
M12 net_8 out1 net_10 net_10 nmos
M13 outfeedback vref net_10 net_10 nmos
M14 net_8 net_8 source_pmos source_pmos pmos
M15 outfeedback outfeedback source_pmos source_pmos pmos
M16 net_9 ibias source_nmos source_nmos nmos
M17 net_10 ibias source_nmos source_nmos nmos
M18 net_3 net_3 net_1 net_1 nmos
M19 ibias ibias source_nmos source_nmos nmos
M20 bias_p_2 bias_p_2 source_pmos source_pmos pmos
M21 bias_p_3 bias_p_3 source_pmos source_pmos pmos
M22 net_3 bias_p_3 source_pmos source_pmos pmos
M23 bias_p_2 ibias source_nmos source_nmos nmos
M24 bias_p_3 ibias source_nmos source_nmos nmos
Cap_load_1 out1 source_nmos
Cap_load_2 out2 source_nmos
.end one_stage_fully_differential_op_amp23
