.suckt  one_stage_fully_differential_op_amp25 ibias in1 in2 out source_nmos source_pmos
M1 out1 in1 net_0 net_0 pmos
M2 out2 in2 net_0 net_0 pmos
M3 out1 outfeedback source_nmos source_nmos nmos
M4 out2 outfeedback source_nmos source_nmos nmos
M5 net_1 ibias source_pmos source_pmos pmos
M6 net_0 bias_p_1 net_1 net_1 pmos
M7 net_4 out2 net_5 net_5 pmos
M8 outfeedback vref net_5 net_5 pmos
M9 net_4 out1 net_6 net_6 pmos
M10 outfeedback vref net_6 net_6 pmos
M11 net_4 net_4 source_nmos source_nmos nmos
M12 outfeedback outfeedback source_nmos source_nmos nmos
M13 net_5 ibias source_pmos source_pmos pmos
M14 net_6 ibias source_pmos source_pmos pmos
M15 bias_p_1 bias_p_1 source_pmos source_pmos pmos
M16 ibias ibias source_pmos source_pmos pmos
M17 bias_n_3 bias_n_3 source_nmos source_nmos nmos
M18 bias_p_1 bias_n_3 source_nmos source_nmos nmos
M19 bias_n_3 ibias source_pmos source_pmos pmos
Cap_load_1 out1 source_nmos
Cap_load_2 out2 source_nmos
.end one_stage_fully_differential_op_amp25
