.suckt  two_stage_fully_differential_op_amp276 ibias in1 in2 out source_nmos source_pmos
M1 net_0 in1 net_1 net_1 nmos
M2 net_2 in2 net_1 net_1 nmos
M3 out1firststage net_3 net_0 net_0 nmos
M4 out2firststage net_3 net_2 net_2 nmos
M5 net_4 outfeedback source_pmos source_pmos pmos
M6 out1firststage bias_p_4 net_4 net_4 pmos
M7 net_6 outfeedback source_pmos source_pmos pmos
M8 out2firststage bias_p_4 net_6 net_6 pmos
M9 net_1 ibias source_nmos source_nmos nmos
M10 net_8 out2 net_9 net_9 nmos
M11 outfeedback vref net_9 net_9 nmos
M12 net_8 out1 net_10 net_10 nmos
M13 outfeedback vref net_10 net_10 nmos
M14 net_8 net_8 source_pmos source_pmos pmos
M15 outfeedback outfeedback source_pmos source_pmos pmos
M16 net_9 ibias source_nmos source_nmos nmos
M17 net_10 ibias source_nmos source_nmos nmos
M18 net_12 out1firststage source_pmos source_pmos pmos
M19 out1 bias_p_4 net_12 net_12 pmos
M20 net_14 net_14 source_nmos source_nmos nmos
M21 out1 net_15 net_14 net_14 nmos
M22 net_16 out2firststage source_pmos source_pmos pmos
M23 out2 bias_p_4 net_16 net_16 pmos
M24 net_18 net_18 source_nmos source_nmos nmos
M25 out2 net_19 net_18 net_18 nmos
M26 net_3 net_3 net_1 net_1 nmos
M27 net_15 net_15 bias_n_1m bias_n_1m nmos
M28 bias_n_1m net_14 source_nmos source_nmos nmos
M29 net_19 net_19 bias_n_2m bias_n_2m nmos
M30 bias_n_2m net_18 source_nmos source_nmos nmos
M31 ibias ibias source_nmos source_nmos nmos
M32 bias_p_4 bias_p_4 source_pmos source_pmos pmos
M33 bias_p_5 bias_p_5 source_pmos source_pmos pmos
M34 net_3 bias_p_5 source_pmos source_pmos pmos
M35 bias_p_4 ibias source_nmos source_nmos nmos
M36 net_15 bias_p_5 source_pmos source_pmos pmos
M37 net_19 bias_p_5 source_pmos source_pmos pmos
M38 bias_p_5 ibias source_nmos source_nmos nmos
Cap_load_1 out1 source_nmos
Cap_load_2 out2 source_nmos
Cap_compensation_1 out1firststage out1
Cap_compensation_2 out2firststage out2
.end two_stage_fully_differential_op_amp276
