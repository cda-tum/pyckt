.suckt  one_stage_fully_differential_op_amp11 ibias in1 in2 out source_nmos source_pmos
M1 net_0 in1 net_1 net_1 pmos
M2 net_2 in2 net_1 net_1 pmos
M3 out1 net_3 net_0 net_0 pmos
M4 out2 net_3 net_2 net_2 pmos
M5 net_4 outfeedback source_nmos source_nmos nmos
M6 out1 bias_n_1 net_4 net_4 nmos
M7 net_6 outfeedback source_nmos source_nmos nmos
M8 out2 bias_n_1 net_6 net_6 nmos
M9 net_1 ibias source_pmos source_pmos pmos
M10 net_8 out2 net_9 net_9 pmos
M11 outfeedback vref net_9 net_9 pmos
M12 net_8 out1 net_10 net_10 pmos
M13 outfeedback vref net_10 net_10 pmos
M14 net_8 net_8 source_nmos source_nmos nmos
M15 outfeedback outfeedback source_nmos source_nmos nmos
M16 net_9 ibias source_pmos source_pmos pmos
M17 net_10 ibias source_pmos source_pmos pmos
M18 bias_n_1 bias_n_1 source_nmos source_nmos nmos
M19 net_3 net_3 net_1 net_1 pmos
M20 ibias ibias source_pmos source_pmos pmos
M21 bias_n_3 bias_n_3 source_nmos source_nmos nmos
M22 bias_n_1 ibias source_pmos source_pmos pmos
M23 net_3 bias_n_3 source_nmos source_nmos nmos
M24 bias_n_3 ibias source_pmos source_pmos pmos
Cap_load_1 out1 source_nmos
Cap_load_2 out2 source_nmos
.end one_stage_fully_differential_op_amp11
