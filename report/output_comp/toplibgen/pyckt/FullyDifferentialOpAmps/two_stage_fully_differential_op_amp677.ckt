.suckt  two_stage_fully_differential_op_amp677 ibias in1 in2 out source_nmos source_pmos
M1 net_0 in1 net_1 net_1 nmos
M2 net_2 in2 net_1 net_1 nmos
M3 net_0 outfeedback source_pmos source_pmos pmos
M4 out1firststage bias_p_5 net_0 net_0 pmos
M5 net_2 outfeedback source_pmos source_pmos pmos
M6 out2firststage bias_p_5 net_2 net_2 pmos
M7 out1firststage ibias source_nmos source_nmos nmos
M8 out2firststage ibias source_nmos source_nmos nmos
M9 net_5 ibias source_nmos source_nmos nmos
M10 net_1 bias_n_1 net_5 net_5 nmos
M11 net_8 out2 net_9 net_9 nmos
M12 outfeedback vref net_9 net_9 nmos
M13 net_8 out1 net_10 net_10 nmos
M14 outfeedback vref net_10 net_10 nmos
M15 net_8 net_8 source_pmos source_pmos pmos
M16 outfeedback outfeedback source_pmos source_pmos pmos
M17 net_9 ibias source_nmos source_nmos nmos
M18 net_10 ibias source_nmos source_nmos nmos
M19 net_12 net_12 source_pmos source_pmos pmos
M20 out1 net_13 net_12 net_12 pmos
M21 out1 out1firststage source_nmos source_nmos nmos
M22 net_14 net_14 source_pmos source_pmos pmos
M23 out2 net_15 net_14 net_14 pmos
M24 out2 out2firststage source_nmos source_nmos nmos
M25 bias_n_1 bias_n_1 source_nmos source_nmos nmos
M26 ibias ibias source_nmos source_nmos nmos
M27 net_13 net_13 bias_p_3m bias_p_3m pmos
M28 bias_p_3m net_12 source_pmos source_pmos pmos
M29 net_15 net_15 bias_p_4m bias_p_4m pmos
M30 bias_p_4m net_14 source_pmos source_pmos pmos
M31 bias_p_5 bias_p_5 source_pmos source_pmos pmos
M32 bias_p_6 bias_p_6 source_pmos source_pmos pmos
M33 net_15 ibias source_nmos source_nmos nmos
M34 bias_n_1 bias_p_6 source_pmos source_pmos pmos
M35 bias_p_5 ibias source_nmos source_nmos nmos
M36 net_13 ibias source_nmos source_nmos nmos
M37 bias_p_6 ibias source_nmos source_nmos nmos
Cap_load_1 out1 source_nmos
Cap_load_2 out2 source_nmos
Cap_compensation_1 out1firststage out1
Cap_compensation_2 out2firststage out2
.end two_stage_fully_differential_op_amp677
