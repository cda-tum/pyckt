.suckt  two_stage_single_output_op_amp275 ibias in1 in2 out source_nmos source_pmos
M1 net_0 in1 net_1 net_1 pmos
M2 outfirststage in2 net_1 net_1 pmos
M3 net_2 net_0 source_nmos source_nmos nmos
M4 net_0 bias_n_1 net_2 net_2 nmos
M5 net_4 net_0 source_nmos source_nmos nmos
M6 outfirststage bias_n_1 net_4 net_4 nmos
M7 net_5 ibias source_pmos source_pmos pmos
M8 net_1 bias_p_3 net_5 net_5 pmos
M9 net_8 outfirststage source_pmos source_pmos pmos
M10 out bias_p_3 net_8 net_8 pmos
M11 net_10 bias_n_2 source_nmos source_nmos nmos
M12 out bias_n_1 net_10 net_10 nmos
M13 bias_n_1 bias_n_1 source_nmos source_nmos nmos
M14 bias_n_2 bias_n_2 source_nmos source_nmos nmos
M15 bias_p_3 bias_p_3 source_pmos source_pmos pmos
M16 ibias ibias source_pmos source_pmos pmos
M17 bias_n_2 ibias source_pmos source_pmos pmos
M18 bias_n_1 ibias source_pmos source_pmos pmos
M19 bias_p_3 bias_n_2 source_nmos source_nmos nmos
Cap_load_1 out source_nmos
Cap_compensation_1 outfirststage out
.end two_stage_single_output_op_amp275
