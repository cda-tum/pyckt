.suckt  two_stage_single_output_op_amp1209 ibias in1 in2 out source_nmos source_pmos
M1 net_0 in1 net_1 net_1 pmos
M2 net_2 in2 net_1 net_1 pmos
M3 net_3 net_4 net_0 net_0 pmos
M4 outfirststage net_4 net_2 net_2 pmos
M5 net_3 net_5 source_nmos source_nmos nmos
M6 net_5 net_5 source_nmos source_nmos nmos
M7 outfirststage net_3 net_5 net_5 nmos
M8 net_6 bias_p_2b source_pmos source_pmos pmos
M9 net_1 bias_p_2t net_6 net_6 pmos
M10 out outfirststage source_pmos source_pmos pmos
M11 net_9 net_9 source_nmos source_nmos nmos
M12 out ibias net_9 net_9 nmos
M13 ibias ibias bias_n_1m bias_n_1m nmos
M14 bias_n_1m net_9 source_nmos source_nmos nmos
M15 net_4 net_4 net_1 net_1 pmos
M16 bias_p_2b bias_p_2b source_pmos source_pmos pmos
M17 bias_p_2t bias_p_2t bias_p_2b bias_p_2b pmos
M18 bias_p_2t net_9 source_nmos source_nmos nmos
M19 net_4 net_9 source_nmos source_nmos nmos
Cap_load_1 out source_nmos
Cap_compensation_1 outfirststage out
.end two_stage_single_output_op_amp1209
