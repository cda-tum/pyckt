.suckt  two_stage_single_output_op_amp437 ibias in1 in2 out source_nmos source_pmos
M1 net_0 in1 net_1 net_1 nmos
M2 outfirststage in2 net_1 net_1 nmos
M3 net_2 net_0 source_pmos source_pmos pmos
M4 net_0 bias_p_3 net_2 net_2 pmos
M5 net_4 net_0 source_pmos source_pmos pmos
M6 outfirststage bias_p_3 net_4 net_4 pmos
M7 net_5 bias_n_1b source_nmos source_nmos nmos
M8 net_1 ibias net_5 net_5 nmos
M9 net_8 net_8 source_pmos source_pmos pmos
M10 out net_9 net_8 net_8 pmos
M11 out outfirststage source_nmos source_nmos nmos
M12 bias_n_1b bias_n_1b source_nmos source_nmos nmos
M13 ibias ibias bias_n_1b bias_n_1b nmos
M14 net_9 net_9 bias_p_2m bias_p_2m pmos
M15 bias_p_2m net_8 source_pmos source_pmos pmos
M16 bias_p_3 bias_p_3 source_pmos source_pmos pmos
M17 net_9 bias_n_1b source_nmos source_nmos nmos
M18 bias_p_3 bias_n_1b source_nmos source_nmos nmos
Cap_load_1 out source_nmos
Cap_compensation_1 outfirststage out
.end two_stage_single_output_op_amp437
