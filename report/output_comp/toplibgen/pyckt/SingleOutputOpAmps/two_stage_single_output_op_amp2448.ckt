.suckt  two_stage_single_output_op_amp2448 ibias in1 in2 out source_nmos source_pmos
M1 net_0 in1 net_1 net_1 nmos
M2 outfirststage in2 net_1 net_1 nmos
M3 net_2 net_3 source_nmos source_nmos nmos
M4 net_0 net_0 net_2 net_2 nmos
M5 net_3 net_3 source_nmos source_nmos nmos
M6 outfirststage net_0 net_3 net_3 nmos
M7 net_0 bias_p_4 source_pmos source_pmos pmos
M8 outfirststage bias_p_4 source_pmos source_pmos pmos
M9 net_5 net_5 source_nmos source_nmos nmos
M10 net_1 net_6 net_5 net_5 nmos
M11 net_7 outfirststage source_pmos source_pmos pmos
M12 out bias_p_3 net_7 net_7 pmos
M13 net_9 net_9 source_nmos source_nmos nmos
M14 out ibias net_9 net_9 nmos
M15 net_6 net_6 bias_n_1m bias_n_1m nmos
M16 bias_n_1m net_5 source_nmos source_nmos nmos
M17 ibias ibias bias_n_2m bias_n_2m nmos
M18 bias_n_2m net_9 source_nmos source_nmos nmos
M19 bias_p_3 bias_p_3 source_pmos source_pmos pmos
M20 bias_p_4 bias_p_4 source_pmos source_pmos pmos
M21 bias_p_4 net_9 source_nmos source_nmos nmos
M22 bias_p_3 net_9 source_nmos source_nmos nmos
M23 net_6 bias_p_4 source_pmos source_pmos pmos
Cap_load_1 out source_nmos
Cap_compensation_1 outfirststage out
.end two_stage_single_output_op_amp2448
