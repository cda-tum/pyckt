.suckt  symmetrical_op_amp205 ibias in1 in2 out source_nmos source_pmos
M1 out2fs in1 net_0 net_0 nmos
M2 inoutputtc in2 net_0 net_0 nmos
M3 net_1 out2fs source_pmos source_pmos pmos
M4 out2fs out2fs net_1 net_1 pmos
M5 net_2 inoutputtc source_pmos source_pmos pmos
M6 inoutputtc inoutputtc net_2 net_2 pmos
M7 net_3 net_3 source_nmos source_nmos nmos
M8 net_0 ibias net_3 net_3 nmos
M9 net_5 out2fs source_pmos source_pmos pmos
M10 out out2fs net_5 net_5 pmos
M11 net_6 instagebias source_nmos source_nmos nmos
M12 out bias_n_2 net_6 net_6 nmos
M13 net_8 inoutputtc source_pmos source_pmos pmos
M14 instagebias inoutputtc net_8 net_8 pmos
M15 instagebias instagebias source_nmos source_nmos nmos
M16 ibias ibias bias_n_1m bias_n_1m nmos
M17 bias_n_1m net_3 source_nmos source_nmos nmos
M18 bias_n_2 bias_n_2 source_nmos source_nmos nmos
M19 bias_p_3 bias_p_3 source_pmos source_pmos pmos
M20 bias_n_2 bias_p_3 source_pmos source_pmos pmos
M21 bias_p_3 net_3 source_nmos source_nmos nmos
Cap_load_1 out source_nmos
.end symmetrical_op_amp205
