.suckt  one_stage_single_output_op_amp167 ibias in1 in2 out source_nmos source_pmos
M1 net_0 in1 net_1 net_1 pmos
M2 out in2 net_1 net_1 pmos
M3 net_2 net_2 source_pmos source_pmos pmos
M4 net_0 net_0 net_2 net_2 pmos
M5 net_3 net_2 source_pmos source_pmos pmos
M6 out net_0 net_3 net_3 pmos
M7 net_0 bias_n_1 source_nmos source_nmos nmos
M8 out bias_n_1 source_nmos source_nmos nmos
M9 net_5 bias_p_2b source_pmos source_pmos pmos
M10 net_1 ibias net_5 net_5 pmos
M11 bias_n_1 bias_n_1 source_nmos source_nmos nmos
M12 bias_p_2b bias_p_2b source_pmos source_pmos pmos
M13 ibias ibias bias_p_2b bias_p_2b pmos
M14 bias_n_1 bias_p_2b source_pmos source_pmos pmos
Cap_load_1 out source_nmos
.end one_stage_single_output_op_amp167
