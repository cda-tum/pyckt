.suckt  two_stage_single_output_op_amp12 ibias in1 in2 out source_nmos source_pmos
M1 net_0 in1 net_1 net_1 pmos
M2 outfirststage in2 net_1 net_1 pmos
M3 net_0 net_0 source_nmos source_nmos nmos
M4 outfirststage net_0 source_nmos source_nmos nmos
M5 net_1 bias_p_3 source_pmos source_pmos pmos
M6 net_3 outfirststage source_pmos source_pmos pmos
M7 out bias_p_2 net_3 net_3 pmos
M8 net_5 net_5 source_nmos source_nmos nmos
M9 out ibias net_5 net_5 nmos
M10 ibias ibias bias_n_1m bias_n_1m nmos
M11 bias_n_1m net_5 source_nmos source_nmos nmos
M12 bias_p_2 bias_p_2 source_pmos source_pmos pmos
M13 bias_p_3 bias_p_3 source_pmos source_pmos pmos
M14 bias_p_3 net_5 source_nmos source_nmos nmos
M15 bias_p_2 net_5 source_nmos source_nmos nmos
Cap_load_1 out source_nmos
Cap_compensation_1 outfirststage out
.end two_stage_single_output_op_amp12
