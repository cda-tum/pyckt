.suckt  two_stage_single_output_op_amp195 ibias in1 in2 out source_nmos source_pmos
M1 net_0 in1 net_1 net_1 pmos
M2 outfirststage in2 net_1 net_1 pmos
M3 net_0 net_2 source_nmos source_nmos nmos
M4 net_2 net_2 source_nmos source_nmos nmos
M5 outfirststage net_0 net_2 net_2 nmos
M6 net_3 bias_p_1b source_pmos source_pmos pmos
M7 net_1 ibias net_3 net_3 pmos
M8 net_6 bias_p_1b source_pmos source_pmos pmos
M9 out ibias net_6 net_6 pmos
M10 out outfirststage source_nmos source_nmos nmos
M11 bias_p_1b bias_p_1b source_pmos source_pmos pmos
M12 ibias ibias bias_p_1b bias_p_1b pmos
Cap_load_1 out source_nmos
Cap_compensation_1 outfirststage out
.end two_stage_single_output_op_amp195
