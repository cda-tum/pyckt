.suckt  two_stage_single_output_op_amp228 ibias in1 in2 out source_nmos source_pmos
M1 net_0 in1 net_1 net_1 pmos
M2 outfirststage in2 net_1 net_1 pmos
M3 net_0 net_0 source_nmos source_nmos nmos
M4 net_2 net_0 source_nmos source_nmos nmos
M5 outfirststage bias_n_2 net_2 net_2 nmos
M6 net_4 ibias source_pmos source_pmos pmos
M7 net_1 bias_p_3 net_4 net_4 pmos
M8 net_7 outfirststage source_pmos source_pmos pmos
M9 out bias_p_3 net_7 net_7 pmos
M10 net_9 net_9 source_nmos source_nmos nmos
M11 out net_10 net_9 net_9 nmos
M12 net_10 net_10 bias_n_1m bias_n_1m nmos
M13 bias_n_1m net_9 source_nmos source_nmos nmos
M14 bias_n_2 bias_n_2 source_nmos source_nmos nmos
M15 bias_p_3 bias_p_3 source_pmos source_pmos pmos
M16 ibias ibias source_pmos source_pmos pmos
M17 bias_n_5 bias_n_5 source_nmos source_nmos nmos
M18 net_10 ibias source_pmos source_pmos pmos
M19 bias_n_2 ibias source_pmos source_pmos pmos
M20 bias_p_3 bias_n_5 source_nmos source_nmos nmos
M21 bias_n_5 ibias source_pmos source_pmos pmos
Cap_load_1 out source_nmos
Cap_compensation_1 outfirststage out
.end two_stage_single_output_op_amp228
