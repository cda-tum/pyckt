.suckt  two_stage_single_output_op_amp2427 ibias in1 in2 out source_nmos source_pmos
M1 net_0 in1 net_1 net_1 nmos
M2 outfirststage in2 net_1 net_1 nmos
M3 net_2 net_3 source_nmos source_nmos nmos
M4 net_0 net_0 net_2 net_2 nmos
M5 net_3 net_3 source_nmos source_nmos nmos
M6 outfirststage net_0 net_3 net_3 nmos
M7 net_0 bias_p_3 source_pmos source_pmos pmos
M8 outfirststage bias_p_3 source_pmos source_pmos pmos
M9 net_5 bias_n_1b source_nmos source_nmos nmos
M10 net_1 ibias net_5 net_5 nmos
M11 net_8 bias_p_3 source_pmos source_pmos pmos
M12 out bias_p_2 net_8 net_8 pmos
M13 out outfirststage source_nmos source_nmos nmos
M14 bias_n_1b bias_n_1b source_nmos source_nmos nmos
M15 ibias ibias bias_n_1b bias_n_1b nmos
M16 bias_p_2 bias_p_2 source_pmos source_pmos pmos
M17 bias_p_3 bias_p_3 source_pmos source_pmos pmos
M18 bias_p_3 bias_n_1b source_nmos source_nmos nmos
M19 bias_p_2 bias_n_1b source_nmos source_nmos nmos
Cap_load_1 out source_nmos
Cap_compensation_1 outfirststage out
.end two_stage_single_output_op_amp2427
