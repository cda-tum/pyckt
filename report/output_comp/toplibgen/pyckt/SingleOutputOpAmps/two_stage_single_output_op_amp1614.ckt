.suckt  two_stage_single_output_op_amp1614 ibias in1 in2 out source_nmos source_pmos
M1 net_0 in1 net_1 net_1 pmos
M2 outfirststage in2 net_1 net_1 pmos
M3 net_2 net_0 source_pmos source_pmos pmos
M4 net_0 bias_p_4 net_2 net_2 pmos
M5 net_4 net_0 source_pmos source_pmos pmos
M6 outfirststage bias_p_4 net_4 net_4 pmos
M7 net_0 ibias source_nmos source_nmos nmos
M8 outfirststage ibias source_nmos source_nmos nmos
M9 net_1 bias_p_5 source_pmos source_pmos pmos
M10 net_7 net_7 source_pmos source_pmos pmos
M11 out net_8 net_7 net_7 pmos
M12 net_9 outfirststage source_nmos source_nmos nmos
M13 out bias_n_1 net_9 net_9 nmos
M14 bias_n_1 bias_n_1 source_nmos source_nmos nmos
M15 ibias ibias source_nmos source_nmos nmos
M16 net_8 net_8 bias_p_3m bias_p_3m pmos
M17 bias_p_3m net_7 source_pmos source_pmos pmos
M18 bias_p_4 bias_p_4 source_pmos source_pmos pmos
M19 bias_p_5 bias_p_5 source_pmos source_pmos pmos
M20 bias_p_5 ibias source_nmos source_nmos nmos
M21 bias_n_1 bias_p_5 source_pmos source_pmos pmos
M22 bias_p_4 ibias source_nmos source_nmos nmos
M23 net_8 ibias source_nmos source_nmos nmos
Cap_load_1 out source_nmos
Cap_compensation_1 outfirststage out
.end two_stage_single_output_op_amp1614
