.suckt  one_stage_single_output_op_amp74 ibias in1 in2 out source_nmos source_pmos
M1 net_0 in1 net_1 net_1 nmos
M2 net_2 in2 net_1 net_1 nmos
M3 net_0 bias_p_2b source_pmos source_pmos pmos
M4 net_4 bias_p_2t net_0 net_0 pmos
M5 net_2 bias_p_2b source_pmos source_pmos pmos
M6 out bias_p_2t net_2 net_2 pmos
M7 net_4 net_6 source_nmos source_nmos nmos
M8 net_6 net_6 source_nmos source_nmos nmos
M9 out net_4 net_6 net_6 nmos
M10 net_7 net_7 source_nmos source_nmos nmos
M11 net_1 ibias net_7 net_7 nmos
M12 ibias ibias bias_n_1m bias_n_1m nmos
M13 bias_n_1m net_7 source_nmos source_nmos nmos
M14 bias_p_2b bias_p_2b source_pmos source_pmos pmos
M15 bias_p_2t bias_p_2t bias_p_2b bias_p_2b pmos
M16 bias_p_2t net_7 source_nmos source_nmos nmos
Cap_load_1 out source_nmos
.end one_stage_single_output_op_amp74
