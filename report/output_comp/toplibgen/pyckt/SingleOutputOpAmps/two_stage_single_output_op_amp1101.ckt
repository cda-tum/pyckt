.suckt  two_stage_single_output_op_amp1101 ibias in1 in2 out source_nmos source_pmos
M1 net_0 in1 net_1 net_1 nmos
M2 net_2 in2 net_1 net_1 nmos
M3 net_3 net_4 net_0 net_0 nmos
M4 outfirststage net_4 net_2 net_2 nmos
M5 net_3 net_3 source_pmos source_pmos pmos
M6 outfirststage net_3 source_pmos source_pmos pmos
M7 net_1 ibias source_nmos source_nmos nmos
M8 out outfirststage source_pmos source_pmos pmos
M9 net_6 net_6 source_nmos source_nmos nmos
M10 out net_7 net_6 net_6 nmos
M11 net_4 net_4 net_1 net_1 nmos
M12 net_7 net_7 bias_n_1m bias_n_1m nmos
M13 bias_n_1m net_6 source_nmos source_nmos nmos
M14 ibias ibias source_nmos source_nmos nmos
M15 bias_p_3 bias_p_3 source_pmos source_pmos pmos
M16 net_4 bias_p_3 source_pmos source_pmos pmos
M17 net_7 bias_p_3 source_pmos source_pmos pmos
M18 bias_p_3 ibias source_nmos source_nmos nmos
Cap_load_1 out source_nmos
Cap_compensation_1 outfirststage out
.end two_stage_single_output_op_amp1101
