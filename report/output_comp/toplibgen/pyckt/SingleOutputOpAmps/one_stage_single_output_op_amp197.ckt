.suckt  one_stage_single_output_op_amp197 ibias in1 in2 out source_nmos source_pmos
M1 net_0 in1 net_1 net_1 nmos
M2 out in2 net_1 net_1 nmos
M3 net_2 net_2 source_nmos source_nmos nmos
M4 net_0 net_0 net_2 net_2 nmos
M5 net_3 net_2 source_nmos source_nmos nmos
M6 out net_0 net_3 net_3 nmos
M7 net_4 bias_p_2b source_pmos source_pmos pmos
M8 net_0 bias_p_2t net_4 net_4 pmos
M9 net_7 bias_p_2b source_pmos source_pmos pmos
M10 out bias_p_2t net_7 net_7 pmos
M11 net_8 bias_n_1b source_nmos source_nmos nmos
M12 net_1 ibias net_8 net_8 nmos
M13 bias_n_1b bias_n_1b source_nmos source_nmos nmos
M14 ibias ibias bias_n_1b bias_n_1b nmos
M15 bias_p_2b bias_p_2b source_pmos source_pmos pmos
M16 bias_p_2t bias_p_2t bias_p_2b bias_p_2b pmos
M17 bias_p_2t bias_n_1b source_nmos source_nmos nmos
Cap_load_1 out source_nmos
.end one_stage_single_output_op_amp197
