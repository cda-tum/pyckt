.suckt  two_stage_single_output_op_amp700 ibias in1 in2 out source_nmos source_pmos
M1 net_0 in1 net_1 net_1 pmos
M2 net_2 in2 net_1 net_1 pmos
M3 net_0 bias_n_2 source_nmos source_nmos nmos
M4 net_4 bias_n_1 net_0 net_0 nmos
M5 net_2 bias_n_2 source_nmos source_nmos nmos
M6 outfirststage bias_n_1 net_2 net_2 nmos
M7 net_4 net_6 source_pmos source_pmos pmos
M8 net_6 net_6 source_pmos source_pmos pmos
M9 outfirststage net_4 net_6 net_6 pmos
M10 net_7 bias_p_3b source_pmos source_pmos pmos
M11 net_1 ibias net_7 net_7 pmos
M12 net_10 bias_p_3b source_pmos source_pmos pmos
M13 out ibias net_10 net_10 pmos
M14 net_13 outfirststage source_nmos source_nmos nmos
M15 out bias_n_1 net_13 net_13 nmos
M16 bias_n_1 bias_n_1 source_nmos source_nmos nmos
M17 bias_n_2 bias_n_2 source_nmos source_nmos nmos
M18 bias_p_3b bias_p_3b source_pmos source_pmos pmos
M19 ibias ibias bias_p_3b bias_p_3b pmos
M20 bias_n_2 bias_p_3b source_pmos source_pmos pmos
M21 bias_n_1 bias_p_3b source_pmos source_pmos pmos
Cap_load_1 out source_nmos
Cap_compensation_1 outfirststage out
.end two_stage_single_output_op_amp700
