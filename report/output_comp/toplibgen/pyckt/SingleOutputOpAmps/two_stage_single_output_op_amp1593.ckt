.suckt  two_stage_single_output_op_amp1593 ibias in1 in2 out source_nmos source_pmos
M1 net_0 in1 net_1 net_1 pmos
M2 outfirststage in2 net_1 net_1 pmos
M3 net_2 net_2 source_pmos source_pmos pmos
M4 net_0 net_0 net_2 net_2 pmos
M5 net_3 net_2 source_pmos source_pmos pmos
M6 outfirststage net_0 net_3 net_3 pmos
M7 net_0 bias_n_2 source_nmos source_nmos nmos
M8 outfirststage bias_n_2 source_nmos source_nmos nmos
M9 net_1 ibias source_pmos source_pmos pmos
M10 out outfirststage source_pmos source_pmos pmos
M11 net_6 net_6 source_nmos source_nmos nmos
M12 out net_7 net_6 net_6 nmos
M13 net_7 net_7 bias_n_1m bias_n_1m nmos
M14 bias_n_1m net_6 source_nmos source_nmos nmos
M15 bias_n_2 bias_n_2 source_nmos source_nmos nmos
M16 ibias ibias source_pmos source_pmos pmos
M17 bias_n_2 ibias source_pmos source_pmos pmos
M18 net_7 ibias source_pmos source_pmos pmos
Cap_load_1 out source_nmos
Cap_compensation_1 outfirststage out
.end two_stage_single_output_op_amp1593
