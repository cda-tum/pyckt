.suckt  one_stage_single_output_op_amp51 ibias in1 in2 out source_nmos source_pmos
M1 net_0 in1 net_1 net_1 nmos
M2 net_2 in2 net_1 net_1 nmos
M3 net_0 bias_p_2b source_pmos source_pmos pmos
M4 net_4 bias_p_2t net_0 net_0 pmos
M5 net_2 bias_p_2b source_pmos source_pmos pmos
M6 out bias_p_2t net_2 net_2 pmos
M7 net_4 net_6 source_nmos source_nmos nmos
M8 net_6 net_6 source_nmos source_nmos nmos
M9 out net_4 net_6 net_6 nmos
M10 net_1 ibias source_nmos source_nmos nmos
M11 ibias ibias source_nmos source_nmos nmos
M12 bias_p_2b bias_p_2b source_pmos source_pmos pmos
M13 bias_p_2t bias_p_2t bias_p_2b bias_p_2b pmos
M14 bias_p_2t ibias source_nmos source_nmos nmos
Cap_load_1 out source_nmos
.end one_stage_single_output_op_amp51
