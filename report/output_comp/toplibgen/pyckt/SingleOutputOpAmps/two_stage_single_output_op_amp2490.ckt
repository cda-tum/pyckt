.suckt  two_stage_single_output_op_amp2490 ibias in1 in2 out source_nmos source_pmos
M1 net_0 in1 net_1 net_1 nmos
M2 outfirststage in2 net_1 net_1 nmos
M3 net_2 net_0 source_nmos source_nmos nmos
M4 net_0 net_0 net_2 net_2 nmos
M5 net_3 net_0 source_nmos source_nmos nmos
M6 outfirststage net_0 net_3 net_3 nmos
M7 net_0 bias_p_4 source_pmos source_pmos pmos
M8 outfirststage bias_p_4 source_pmos source_pmos pmos
M9 net_5 net_5 source_nmos source_nmos nmos
M10 net_1 ibias net_5 net_5 nmos
M11 net_7 net_7 source_pmos source_pmos pmos
M12 out net_8 net_7 net_7 pmos
M13 net_9 outfirststage source_nmos source_nmos nmos
M14 out bias_n_2 net_9 net_9 nmos
M15 ibias ibias bias_n_1m bias_n_1m nmos
M16 bias_n_1m net_5 source_nmos source_nmos nmos
M17 bias_n_2 bias_n_2 source_nmos source_nmos nmos
M18 net_8 net_8 bias_p_3m bias_p_3m pmos
M19 bias_p_3m net_7 source_pmos source_pmos pmos
M20 bias_p_4 bias_p_4 source_pmos source_pmos pmos
M21 bias_p_4 net_5 source_nmos source_nmos nmos
M22 bias_n_2 bias_p_4 source_pmos source_pmos pmos
M23 net_8 net_5 source_nmos source_nmos nmos
Cap_load_1 out source_nmos
Cap_compensation_1 outfirststage out
.end two_stage_single_output_op_amp2490
