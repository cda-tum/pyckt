.suckt  two_stage_single_output_op_amp1739 ibias in1 in2 out source_nmos source_pmos
M1 net_0 in1 net_1 net_1 nmos
M2 outfirststage in2 net_1 net_1 nmos
M3 net_0 net_0 source_nmos source_nmos nmos
M4 net_2 net_0 source_nmos source_nmos nmos
M5 outfirststage bias_n_1 net_2 net_2 nmos
M6 net_0 bias_p_4 source_pmos source_pmos pmos
M7 outfirststage bias_p_4 source_pmos source_pmos pmos
M8 net_1 ibias source_nmos source_nmos nmos
M9 net_6 outfirststage source_pmos source_pmos pmos
M10 out bias_p_3 net_6 net_6 pmos
M11 net_8 ibias source_nmos source_nmos nmos
M12 out bias_n_1 net_8 net_8 nmos
M13 bias_n_1 bias_n_1 source_nmos source_nmos nmos
M14 ibias ibias source_nmos source_nmos nmos
M15 bias_p_3 bias_p_3 source_pmos source_pmos pmos
M16 bias_p_4 bias_p_4 source_pmos source_pmos pmos
M17 bias_p_4 ibias source_nmos source_nmos nmos
M18 bias_n_1 bias_p_4 source_pmos source_pmos pmos
M19 bias_p_3 ibias source_nmos source_nmos nmos
Cap_load_1 out source_nmos
Cap_compensation_1 outfirststage out
.end two_stage_single_output_op_amp1739
