.suckt  two_stage_single_output_op_amp259 ibias in1 in2 out source_nmos source_pmos
M1 net_0 in1 net_1 net_1 pmos
M2 outfirststage in2 net_1 net_1 pmos
M3 net_2 net_2 source_nmos source_nmos nmos
M4 net_0 net_0 net_2 net_2 nmos
M5 net_3 net_2 source_nmos source_nmos nmos
M6 outfirststage net_0 net_3 net_3 nmos
M7 net_4 net_4 source_pmos source_pmos pmos
M8 net_1 ibias net_4 net_4 pmos
M9 out outfirststage source_pmos source_pmos pmos
M10 out bias_n_1 source_nmos source_nmos nmos
M11 bias_n_1 bias_n_1 source_nmos source_nmos nmos
M12 ibias ibias bias_p_2m bias_p_2m pmos
M13 bias_p_2m net_4 source_pmos source_pmos pmos
M14 bias_n_1 net_4 source_pmos source_pmos pmos
Cap_load_1 out source_nmos
Cap_compensation_1 outfirststage out
.end two_stage_single_output_op_amp259
