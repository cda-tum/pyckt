.suckt  one_stage_single_output_op_amp203 ibias in1 in2 out source_nmos source_pmos
M1 net_0 in1 net_1 net_1 nmos
M2 out in2 net_1 net_1 nmos
M3 net_2 net_3 source_nmos source_nmos nmos
M4 net_0 net_0 net_2 net_2 nmos
M5 net_3 net_3 source_nmos source_nmos nmos
M6 out net_0 net_3 net_3 nmos
M7 net_0 bias_p_2 source_pmos source_pmos pmos
M8 out bias_p_2 source_pmos source_pmos pmos
M9 net_5 bias_n_1b source_nmos source_nmos nmos
M10 net_1 ibias net_5 net_5 nmos
M11 bias_n_1b bias_n_1b source_nmos source_nmos nmos
M12 ibias ibias bias_n_1b bias_n_1b nmos
M13 bias_p_2 bias_p_2 source_pmos source_pmos pmos
M14 bias_p_2 bias_n_1b source_nmos source_nmos nmos
Cap_load_1 out source_nmos
.end one_stage_single_output_op_amp203
