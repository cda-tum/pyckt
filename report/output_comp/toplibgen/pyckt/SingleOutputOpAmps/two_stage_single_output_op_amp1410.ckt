.suckt  two_stage_single_output_op_amp1410 ibias in1 in2 out source_nmos source_pmos
M1 net_0 in1 net_1 net_1 nmos
M2 net_2 in2 net_1 net_1 nmos
M3 net_3 net_4 net_0 net_0 nmos
M4 outfirststage net_4 net_2 net_2 nmos
M5 net_3 net_3 source_pmos source_pmos pmos
M6 net_5 net_3 source_pmos source_pmos pmos
M7 outfirststage bias_p_4 net_5 net_5 pmos
M8 net_7 net_7 source_nmos source_nmos nmos
M9 net_1 net_8 net_7 net_7 nmos
M10 net_9 net_9 source_pmos source_pmos pmos
M11 out ibias net_9 net_9 pmos
M12 net_11 outfirststage source_nmos source_nmos nmos
M13 out bias_n_2 net_11 net_11 nmos
M14 net_4 net_4 net_1 net_1 nmos
M15 net_8 net_8 bias_n_1m bias_n_1m nmos
M16 bias_n_1m net_7 source_nmos source_nmos nmos
M17 bias_n_2 bias_n_2 source_nmos source_nmos nmos
M18 ibias ibias bias_p_3m bias_p_3m pmos
M19 bias_p_3m net_9 source_pmos source_pmos pmos
M20 bias_p_4 bias_p_4 source_pmos source_pmos pmos
M21 bias_n_5 bias_n_5 source_nmos source_nmos nmos
M22 net_8 net_9 source_pmos source_pmos pmos
M23 net_4 net_9 source_pmos source_pmos pmos
M24 bias_n_2 net_9 source_pmos source_pmos pmos
M25 bias_p_4 bias_n_5 source_nmos source_nmos nmos
M26 bias_n_5 net_9 source_pmos source_pmos pmos
Cap_load_1 out source_nmos
Cap_compensation_1 outfirststage out
.end two_stage_single_output_op_amp1410
