.suckt  two_stage_single_output_op_amp1122 ibias in1 in2 out source_nmos source_pmos
M1 net_0 in1 net_1 net_1 nmos
M2 net_2 in2 net_1 net_1 nmos
M3 net_3 net_4 net_0 net_0 nmos
M4 outfirststage net_4 net_2 net_2 nmos
M5 net_3 net_3 source_pmos source_pmos pmos
M6 net_5 net_3 source_pmos source_pmos pmos
M7 outfirststage bias_p_4 net_5 net_5 pmos
M8 net_1 bias_n_2 source_nmos source_nmos nmos
M9 net_8 net_8 source_pmos source_pmos pmos
M10 out ibias net_8 net_8 pmos
M11 net_10 outfirststage source_nmos source_nmos nmos
M12 out bias_n_1 net_10 net_10 nmos
M13 net_4 net_4 net_1 net_1 nmos
M14 bias_n_1 bias_n_1 source_nmos source_nmos nmos
M15 bias_n_2 bias_n_2 source_nmos source_nmos nmos
M16 ibias ibias bias_p_3m bias_p_3m pmos
M17 bias_p_3m net_8 source_pmos source_pmos pmos
M18 bias_p_4 bias_p_4 source_pmos source_pmos pmos
M19 bias_n_2 net_8 source_pmos source_pmos pmos
M20 net_4 net_8 source_pmos source_pmos pmos
M21 bias_n_1 net_8 source_pmos source_pmos pmos
M22 bias_p_4 bias_n_2 source_nmos source_nmos nmos
Cap_load_1 out source_nmos
Cap_compensation_1 outfirststage out
.end two_stage_single_output_op_amp1122
