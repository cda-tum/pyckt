.suckt  two_stage_single_output_op_amp185 ibias in1 in2 out source_nmos source_pmos
M1 net_0 in1 net_1 net_1 pmos
M2 outfirststage in2 net_1 net_1 pmos
M3 net_0 net_0 source_nmos source_nmos nmos
M4 outfirststage net_0 source_nmos source_nmos nmos
M5 net_2 net_2 source_pmos source_pmos pmos
M6 net_1 net_3 net_2 net_2 pmos
M7 net_4 net_4 source_pmos source_pmos pmos
M8 out ibias net_4 net_4 pmos
M9 out outfirststage source_nmos source_nmos nmos
M10 net_3 net_3 bias_p_1m bias_p_1m pmos
M11 bias_p_1m net_2 source_pmos source_pmos pmos
M12 ibias ibias bias_p_2m bias_p_2m pmos
M13 bias_p_2m net_4 source_pmos source_pmos pmos
M14 bias_n_3 bias_n_3 source_nmos source_nmos nmos
M15 net_3 bias_n_3 source_nmos source_nmos nmos
M16 bias_n_3 net_4 source_pmos source_pmos pmos
Cap_load_1 out source_nmos
Cap_compensation_1 outfirststage out
.end two_stage_single_output_op_amp185
