.suckt  symmetrical_op_amp203 ibias in1 in2 out source_nmos source_pmos
M1 out2fs in1 net_0 net_0 nmos
M2 inoutputtc in2 net_0 net_0 nmos
M3 net_1 out2fs source_pmos source_pmos pmos
M4 out2fs out2fs net_1 net_1 pmos
M5 net_2 inoutputtc source_pmos source_pmos pmos
M6 inoutputtc inoutputtc net_2 net_2 pmos
M7 net_3 bias_n_1b source_nmos source_nmos nmos
M8 net_0 ibias net_3 net_3 nmos
M9 net_6 out2fs source_pmos source_pmos pmos
M10 out out2fs net_6 net_6 pmos
M11 insourcestagebias insourcestagebias source_nmos source_nmos nmos
M12 out inoutputstagebias insourcestagebias insourcestagebias nmos
M13 net_7 inoutputtc source_pmos source_pmos pmos
M14 inoutputstagebias inoutputtc net_7 net_7 pmos
M15 net_8 insourcestagebias source_nmos source_nmos nmos
M16 inoutputstagebias inoutputstagebias net_8 net_8 nmos
M17 bias_n_1b bias_n_1b source_nmos source_nmos nmos
M18 ibias ibias bias_n_1b bias_n_1b nmos
Cap_load_1 out source_nmos
.end symmetrical_op_amp203
