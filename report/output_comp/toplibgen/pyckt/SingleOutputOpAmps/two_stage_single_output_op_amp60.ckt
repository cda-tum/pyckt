.suckt  two_stage_single_output_op_amp60 ibias in1 in2 out source_nmos source_pmos
M1 net_0 in1 net_1 net_1 pmos
M2 outfirststage in2 net_1 net_1 pmos
M3 net_2 net_0 source_nmos source_nmos nmos
M4 net_0 bias_n_2 net_2 net_2 nmos
M5 net_4 net_0 source_nmos source_nmos nmos
M6 outfirststage bias_n_2 net_4 net_4 nmos
M7 net_1 ibias source_pmos source_pmos pmos
M8 net_6 outfirststage source_pmos source_pmos pmos
M9 out bias_p_3 net_6 net_6 pmos
M10 net_8 net_8 source_nmos source_nmos nmos
M11 out net_9 net_8 net_8 nmos
M12 net_9 net_9 bias_n_1m bias_n_1m nmos
M13 bias_n_1m net_8 source_nmos source_nmos nmos
M14 bias_n_2 bias_n_2 source_nmos source_nmos nmos
M15 bias_p_3 bias_p_3 source_pmos source_pmos pmos
M16 ibias ibias source_pmos source_pmos pmos
M17 bias_n_5 bias_n_5 source_nmos source_nmos nmos
M18 net_9 ibias source_pmos source_pmos pmos
M19 bias_n_2 ibias source_pmos source_pmos pmos
M20 bias_p_3 bias_n_5 source_nmos source_nmos nmos
M21 bias_n_5 ibias source_pmos source_pmos pmos
Cap_load_1 out source_nmos
Cap_compensation_1 outfirststage out
.end two_stage_single_output_op_amp60
