.suckt  two_stage_single_output_op_amp2296 ibias in1 in2 out source_nmos source_pmos
M1 net_0 in1 net_1 net_1 nmos
M2 outfirststage in2 net_1 net_1 nmos
M3 net_0 net_0 source_nmos source_nmos nmos
M4 net_2 net_0 source_nmos source_nmos nmos
M5 outfirststage bias_n_2 net_2 net_2 nmos
M6 net_0 bias_p_4 source_pmos source_pmos pmos
M7 outfirststage bias_p_4 source_pmos source_pmos pmos
M8 net_5 net_5 source_nmos source_nmos nmos
M9 net_1 ibias net_5 net_5 nmos
M10 net_7 bias_p_4 source_pmos source_pmos pmos
M11 out bias_p_3 net_7 net_7 pmos
M12 net_10 outfirststage source_nmos source_nmos nmos
M13 out bias_n_2 net_10 net_10 nmos
M14 ibias ibias bias_n_1m bias_n_1m nmos
M15 bias_n_1m net_5 source_nmos source_nmos nmos
M16 bias_n_2 bias_n_2 source_nmos source_nmos nmos
M17 bias_p_3 bias_p_3 source_pmos source_pmos pmos
M18 bias_p_4 bias_p_4 source_pmos source_pmos pmos
M19 bias_p_4 net_5 source_nmos source_nmos nmos
M20 bias_n_2 bias_p_4 source_pmos source_pmos pmos
M21 bias_p_3 net_5 source_nmos source_nmos nmos
Cap_load_1 out source_nmos
Cap_compensation_1 outfirststage out
.end two_stage_single_output_op_amp2296
