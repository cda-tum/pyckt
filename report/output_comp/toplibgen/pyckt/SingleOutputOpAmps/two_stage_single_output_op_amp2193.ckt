.suckt  two_stage_single_output_op_amp2193 ibias in1 in2 out source_nmos source_pmos
M1 net_0 in1 net_1 net_1 nmos
M2 outfirststage in2 net_1 net_1 nmos
M3 net_0 net_0 source_nmos source_nmos nmos
M4 outfirststage net_0 source_nmos source_nmos nmos
M5 net_0 ibias source_pmos source_pmos pmos
M6 outfirststage ibias source_pmos source_pmos pmos
M7 net_3 bias_n_2b source_nmos source_nmos nmos
M8 net_1 bias_n_2t net_3 net_3 nmos
M9 out outfirststage source_pmos source_pmos pmos
M10 net_6 net_6 source_nmos source_nmos nmos
M11 out net_7 net_6 net_6 nmos
M12 net_7 net_7 bias_n_1m bias_n_1m nmos
M13 bias_n_1m net_6 source_nmos source_nmos nmos
M14 bias_n_2b bias_n_2b source_nmos source_nmos nmos
M15 bias_n_2t bias_n_2t bias_n_2b bias_n_2b nmos
M16 ibias ibias source_pmos source_pmos pmos
M17 bias_n_2t ibias source_pmos source_pmos pmos
M18 net_7 ibias source_pmos source_pmos pmos
Cap_load_1 out source_nmos
Cap_compensation_1 outfirststage out
.end two_stage_single_output_op_amp2193
