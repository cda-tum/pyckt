.suckt  two_stage_single_output_op_amp91 ibias in1 in2 out source_nmos source_pmos
M1 net_0 in1 net_1 net_1 nmos
M2 outfirststage in2 net_1 net_1 nmos
M3 net_0 net_0 source_pmos source_pmos pmos
M4 outfirststage net_0 source_pmos source_pmos pmos
M5 net_1 ibias source_nmos source_nmos nmos
M6 out outfirststage source_pmos source_pmos pmos
M7 out ibias source_nmos source_nmos nmos
M8 ibias ibias source_nmos source_nmos nmos
Cap_load_1 out source_nmos
Cap_compensation_1 outfirststage out
.end two_stage_single_output_op_amp91
