.suckt  symmetrical_op_amp148 ibias in1 in2 out source_nmos source_pmos
M1 out1fs in1 net_0 net_0 pmos
M2 insourcetc in2 net_0 net_0 pmos
M3 net_1 out1fs source_nmos source_nmos nmos
M4 out1fs bias_n_1 net_1 net_1 nmos
M5 net_2 insourcetc source_nmos source_nmos nmos
M6 insourcetc bias_n_1 net_2 net_2 nmos
M7 net_3 net_3 source_pmos source_pmos pmos
M8 net_0 ibias net_3 net_3 pmos
M9 out instagebias source_pmos source_pmos pmos
M10 net_5 out1fs source_nmos source_nmos nmos
M11 out bias_n_1 net_5 net_5 nmos
M12 net_6 insourcetc source_nmos source_nmos nmos
M13 instagebias bias_n_1 net_6 net_6 nmos
M14 instagebias instagebias source_pmos source_pmos pmos
M15 bias_n_1 bias_n_1 source_nmos source_nmos nmos
M16 ibias ibias bias_p_2m bias_p_2m pmos
M17 bias_p_2m net_3 source_pmos source_pmos pmos
M18 bias_n_1 net_3 source_pmos source_pmos pmos
Cap_load_1 out source_nmos
.end symmetrical_op_amp148
