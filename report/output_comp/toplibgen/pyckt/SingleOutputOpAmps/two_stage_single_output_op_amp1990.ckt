.suckt  two_stage_single_output_op_amp1990 ibias in1 in2 out source_nmos source_pmos
M1 net_0 in1 net_1 net_1 pmos
M2 outfirststage in2 net_1 net_1 pmos
M3 net_0 net_0 source_pmos source_pmos pmos
M4 net_2 net_0 source_pmos source_pmos pmos
M5 outfirststage bias_p_4 net_2 net_2 pmos
M6 net_4 bias_n_2 source_nmos source_nmos nmos
M7 net_0 bias_n_1 net_4 net_4 nmos
M8 net_7 bias_n_2 source_nmos source_nmos nmos
M9 outfirststage bias_n_1 net_7 net_7 nmos
M10 net_8 net_8 source_pmos source_pmos pmos
M11 net_1 ibias net_8 net_8 pmos
M12 net_10 outfirststage source_pmos source_pmos pmos
M13 out bias_p_4 net_10 net_10 pmos
M14 out bias_n_2 source_nmos source_nmos nmos
M15 bias_n_1 bias_n_1 source_nmos source_nmos nmos
M16 bias_n_2 bias_n_2 source_nmos source_nmos nmos
M17 ibias ibias bias_p_3m bias_p_3m pmos
M18 bias_p_3m net_8 source_pmos source_pmos pmos
M19 bias_p_4 bias_p_4 source_pmos source_pmos pmos
M20 bias_n_2 net_8 source_pmos source_pmos pmos
M21 bias_n_1 net_8 source_pmos source_pmos pmos
M22 bias_p_4 bias_n_2 source_nmos source_nmos nmos
Cap_load_1 out source_nmos
Cap_compensation_1 outfirststage out
.end two_stage_single_output_op_amp1990
