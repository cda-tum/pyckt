.suckt  two_stage_single_output_op_amp1489 ibias in1 in2 out source_nmos source_pmos
M1 net_0 in1 net_1 net_1 nmos
M2 net_2 in2 net_1 net_1 nmos
M3 net_3 net_4 net_0 net_0 nmos
M4 outfirststage net_4 net_2 net_2 nmos
M5 net_5 net_3 source_pmos source_pmos pmos
M6 net_3 net_3 net_5 net_5 pmos
M7 net_6 net_3 source_pmos source_pmos pmos
M8 outfirststage net_3 net_6 net_6 pmos
M9 net_7 bias_n_1b source_nmos source_nmos nmos
M10 net_1 bias_n_1t net_7 net_7 nmos
M11 out ibias source_pmos source_pmos pmos
M12 out outfirststage source_nmos source_nmos nmos
M13 net_4 net_4 net_1 net_1 nmos
M14 bias_n_1b bias_n_1b source_nmos source_nmos nmos
M15 bias_n_1t bias_n_1t bias_n_1b bias_n_1b nmos
M16 ibias ibias source_pmos source_pmos pmos
M17 bias_n_1t ibias source_pmos source_pmos pmos
M18 net_4 ibias source_pmos source_pmos pmos
Cap_load_1 out source_nmos
Cap_compensation_1 outfirststage out
.end two_stage_single_output_op_amp1489
