.suckt  two_stage_single_output_op_amp312 ibias in1 in2 out source_nmos source_pmos
M1 net_0 in1 net_1 net_1 pmos
M2 outfirststage in2 net_1 net_1 pmos
M3 net_2 net_3 source_nmos source_nmos nmos
M4 net_0 net_0 net_2 net_2 nmos
M5 net_3 net_3 source_nmos source_nmos nmos
M6 outfirststage net_0 net_3 net_3 nmos
M7 net_4 net_4 source_pmos source_pmos pmos
M8 net_1 net_5 net_4 net_4 pmos
M9 net_6 outfirststage source_pmos source_pmos pmos
M10 out bias_p_3 net_6 net_6 pmos
M11 net_8 net_8 source_nmos source_nmos nmos
M12 out ibias net_8 net_8 nmos
M13 ibias ibias bias_n_1m bias_n_1m nmos
M14 bias_n_1m net_8 source_nmos source_nmos nmos
M15 net_5 net_5 bias_p_2m bias_p_2m pmos
M16 bias_p_2m net_4 source_pmos source_pmos pmos
M17 bias_p_3 bias_p_3 source_pmos source_pmos pmos
M18 net_5 net_8 source_nmos source_nmos nmos
M19 bias_p_3 net_8 source_nmos source_nmos nmos
Cap_load_1 out source_nmos
Cap_compensation_1 outfirststage out
.end two_stage_single_output_op_amp312
