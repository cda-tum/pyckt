.suckt  two_stage_single_output_op_amp286 ibias in1 in2 out source_nmos source_pmos
M1 net_0 in1 net_1 net_1 pmos
M2 outfirststage in2 net_1 net_1 pmos
M3 net_2 net_0 source_nmos source_nmos nmos
M4 net_0 bias_n_1 net_2 net_2 nmos
M5 net_4 net_0 source_nmos source_nmos nmos
M6 outfirststage bias_n_1 net_4 net_4 nmos
M7 net_5 net_5 source_pmos source_pmos pmos
M8 net_1 ibias net_5 net_5 pmos
M9 net_7 outfirststage source_pmos source_pmos pmos
M10 out bias_p_4 net_7 net_7 pmos
M11 out bias_n_2 source_nmos source_nmos nmos
M12 bias_n_1 bias_n_1 source_nmos source_nmos nmos
M13 bias_n_2 bias_n_2 source_nmos source_nmos nmos
M14 ibias ibias bias_p_3m bias_p_3m pmos
M15 bias_p_3m net_5 source_pmos source_pmos pmos
M16 bias_p_4 bias_p_4 source_pmos source_pmos pmos
M17 bias_n_2 net_5 source_pmos source_pmos pmos
M18 bias_n_1 net_5 source_pmos source_pmos pmos
M19 bias_p_4 bias_n_2 source_nmos source_nmos nmos
Cap_load_1 out source_nmos
Cap_compensation_1 outfirststage out
.end two_stage_single_output_op_amp286
