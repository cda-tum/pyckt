.suckt  two_stage_single_output_op_amp2364 ibias in1 in2 out source_nmos source_pmos
M1 net_0 in1 net_1 net_1 nmos
M2 outfirststage in2 net_1 net_1 nmos
M3 net_2 net_2 source_nmos source_nmos nmos
M4 net_0 net_0 net_2 net_2 nmos
M5 net_3 net_2 source_nmos source_nmos nmos
M6 outfirststage net_0 net_3 net_3 nmos
M7 net_4 bias_p_4 source_pmos source_pmos pmos
M8 net_0 bias_p_3 net_4 net_4 pmos
M9 net_7 bias_p_4 source_pmos source_pmos pmos
M10 outfirststage bias_p_3 net_7 net_7 pmos
M11 net_8 bias_n_2b source_nmos source_nmos nmos
M12 net_1 ibias net_8 net_8 nmos
M13 net_11 outfirststage source_pmos source_pmos pmos
M14 out bias_p_3 net_11 net_11 pmos
M15 net_13 net_13 source_nmos source_nmos nmos
M16 out net_14 net_13 net_13 nmos
M17 net_14 net_14 bias_n_1m bias_n_1m nmos
M18 bias_n_1m net_13 source_nmos source_nmos nmos
M19 bias_n_2b bias_n_2b source_nmos source_nmos nmos
M20 ibias ibias bias_n_2b bias_n_2b nmos
M21 bias_p_3 bias_p_3 source_pmos source_pmos pmos
M22 bias_p_4 bias_p_4 source_pmos source_pmos pmos
M23 bias_p_4 bias_n_2b source_nmos source_nmos nmos
M24 bias_p_3 bias_n_2b source_nmos source_nmos nmos
M25 net_14 bias_p_4 source_pmos source_pmos pmos
Cap_load_1 out source_nmos
Cap_compensation_1 outfirststage out
.end two_stage_single_output_op_amp2364
