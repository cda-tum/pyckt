.suckt  two_stage_single_output_op_amp2058 ibias in1 in2 out source_nmos source_pmos
M1 net_0 in1 net_1 net_1 pmos
M2 outfirststage in2 net_1 net_1 pmos
M3 net_2 net_0 source_pmos source_pmos pmos
M4 net_0 bias_p_5 net_2 net_2 pmos
M5 net_4 net_0 source_pmos source_pmos pmos
M6 outfirststage bias_p_5 net_4 net_4 pmos
M7 net_0 ibias source_nmos source_nmos nmos
M8 outfirststage ibias source_nmos source_nmos nmos
M9 net_6 net_6 source_pmos source_pmos pmos
M10 net_1 net_7 net_6 net_6 pmos
M11 net_8 net_8 source_pmos source_pmos pmos
M12 out net_9 net_8 net_8 pmos
M13 net_10 outfirststage source_nmos source_nmos nmos
M14 out bias_n_1 net_10 net_10 nmos
M15 bias_n_1 bias_n_1 source_nmos source_nmos nmos
M16 ibias ibias source_nmos source_nmos nmos
M17 net_7 net_7 bias_p_3m bias_p_3m pmos
M18 bias_p_3m net_6 source_pmos source_pmos pmos
M19 net_9 net_9 bias_p_4m bias_p_4m pmos
M20 bias_p_4m net_8 source_pmos source_pmos pmos
M21 bias_p_5 bias_p_5 source_pmos source_pmos pmos
M22 bias_p_6 bias_p_6 source_pmos source_pmos pmos
M23 net_9 ibias source_nmos source_nmos nmos
M24 bias_n_1 bias_p_6 source_pmos source_pmos pmos
M25 bias_p_5 ibias source_nmos source_nmos nmos
M26 net_7 ibias source_nmos source_nmos nmos
M27 bias_p_6 ibias source_nmos source_nmos nmos
Cap_load_1 out source_nmos
Cap_compensation_1 outfirststage out
.end two_stage_single_output_op_amp2058
