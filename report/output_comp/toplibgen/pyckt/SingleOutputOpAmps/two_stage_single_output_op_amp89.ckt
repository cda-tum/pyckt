.suckt  two_stage_single_output_op_amp89 ibias in1 in2 out source_nmos source_pmos
M1 net_0 in1 net_1 net_1 nmos
M2 outfirststage in2 net_1 net_1 nmos
M3 net_0 net_0 source_pmos source_pmos pmos
M4 outfirststage net_0 source_pmos source_pmos pmos
M5 net_1 ibias source_nmos source_nmos nmos
M6 net_3 net_3 source_pmos source_pmos pmos
M7 out net_4 net_3 net_3 pmos
M8 out outfirststage source_nmos source_nmos nmos
M9 ibias ibias source_nmos source_nmos nmos
M10 net_4 net_4 bias_p_2m bias_p_2m pmos
M11 bias_p_2m net_3 source_pmos source_pmos pmos
M12 net_4 ibias source_nmos source_nmos nmos
Cap_load_1 out source_nmos
Cap_compensation_1 outfirststage out
.end two_stage_single_output_op_amp89
