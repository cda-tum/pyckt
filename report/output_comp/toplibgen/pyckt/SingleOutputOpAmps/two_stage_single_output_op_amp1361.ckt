.suckt  two_stage_single_output_op_amp1361 ibias in1 in2 out source_nmos source_pmos
M1 net_0 in1 net_1 net_1 nmos
M2 net_2 in2 net_1 net_1 nmos
M3 net_3 net_4 net_0 net_0 nmos
M4 outfirststage net_4 net_2 net_2 nmos
M5 net_3 net_3 source_pmos source_pmos pmos
M6 outfirststage net_3 source_pmos source_pmos pmos
M7 net_5 net_5 source_nmos source_nmos nmos
M8 net_1 net_6 net_5 net_5 nmos
M9 net_7 net_7 source_pmos source_pmos pmos
M10 out ibias net_7 net_7 pmos
M11 out outfirststage source_nmos source_nmos nmos
M12 net_4 net_4 net_1 net_1 nmos
M13 net_6 net_6 bias_n_1m bias_n_1m nmos
M14 bias_n_1m net_5 source_nmos source_nmos nmos
M15 ibias ibias bias_p_2m bias_p_2m pmos
M16 bias_p_2m net_7 source_pmos source_pmos pmos
M17 net_6 net_7 source_pmos source_pmos pmos
M18 net_4 net_7 source_pmos source_pmos pmos
Cap_load_1 out source_nmos
Cap_compensation_1 outfirststage out
.end two_stage_single_output_op_amp1361
