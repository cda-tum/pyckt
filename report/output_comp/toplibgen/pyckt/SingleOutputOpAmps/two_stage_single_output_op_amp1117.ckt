.suckt  two_stage_single_output_op_amp1117 ibias in1 in2 out source_nmos source_pmos
M1 net_0 in1 net_1 net_1 nmos
M2 net_2 in2 net_1 net_1 nmos
M3 net_3 net_4 net_0 net_0 nmos
M4 outfirststage net_4 net_2 net_2 nmos
M5 net_3 net_3 source_pmos source_pmos pmos
M6 net_5 net_3 source_pmos source_pmos pmos
M7 outfirststage bias_p_2 net_5 net_5 pmos
M8 net_1 ibias source_nmos source_nmos nmos
M9 out bias_p_3 source_pmos source_pmos pmos
M10 out outfirststage source_nmos source_nmos nmos
M11 net_4 net_4 net_1 net_1 nmos
M12 ibias ibias source_nmos source_nmos nmos
M13 bias_p_2 bias_p_2 source_pmos source_pmos pmos
M14 bias_p_3 bias_p_3 source_pmos source_pmos pmos
M15 bias_p_3 ibias source_nmos source_nmos nmos
M16 net_4 bias_p_3 source_pmos source_pmos pmos
M17 bias_p_2 ibias source_nmos source_nmos nmos
Cap_load_1 out source_nmos
Cap_compensation_1 outfirststage out
.end two_stage_single_output_op_amp1117
