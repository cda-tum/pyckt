.suckt  two_stage_single_output_op_amp2057 ibias in1 in2 out source_nmos source_pmos
M1 net_0 in1 net_1 net_1 pmos
M2 outfirststage in2 net_1 net_1 pmos
M3 net_2 net_0 source_pmos source_pmos pmos
M4 net_0 bias_p_4 net_2 net_2 pmos
M5 net_4 net_0 source_pmos source_pmos pmos
M6 outfirststage bias_p_4 net_4 net_4 pmos
M7 net_0 ibias source_nmos source_nmos nmos
M8 outfirststage ibias source_nmos source_nmos nmos
M9 net_6 net_6 source_pmos source_pmos pmos
M10 net_1 net_7 net_6 net_6 pmos
M11 net_8 net_8 source_pmos source_pmos pmos
M12 out net_9 net_8 net_8 pmos
M13 out outfirststage source_nmos source_nmos nmos
M14 ibias ibias source_nmos source_nmos nmos
M15 net_7 net_7 bias_p_2m bias_p_2m pmos
M16 bias_p_2m net_6 source_pmos source_pmos pmos
M17 net_9 net_9 bias_p_3m bias_p_3m pmos
M18 bias_p_3m net_8 source_pmos source_pmos pmos
M19 bias_p_4 bias_p_4 source_pmos source_pmos pmos
M20 net_9 ibias source_nmos source_nmos nmos
M21 bias_p_4 ibias source_nmos source_nmos nmos
M22 net_7 ibias source_nmos source_nmos nmos
Cap_load_1 out source_nmos
Cap_compensation_1 outfirststage out
.end two_stage_single_output_op_amp2057
