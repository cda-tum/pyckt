.suckt  two_stage_single_output_op_amp7 ibias in1 in2 out source_nmos source_pmos
M1 net_0 in1 net_1 net_1 pmos
M2 outfirststage in2 net_1 net_1 pmos
M3 net_0 net_0 source_nmos source_nmos nmos
M4 outfirststage net_0 source_nmos source_nmos nmos
M5 net_1 ibias source_pmos source_pmos pmos
M6 out outfirststage source_pmos source_pmos pmos
M7 out bias_n_1 source_nmos source_nmos nmos
M8 bias_n_1 bias_n_1 source_nmos source_nmos nmos
M9 ibias ibias source_pmos source_pmos pmos
M10 bias_n_1 ibias source_pmos source_pmos pmos
Cap_load_1 out source_nmos
Cap_compensation_1 outfirststage out
.end two_stage_single_output_op_amp7
