.suckt  two_stage_single_output_op_amp1198 ibias in1 in2 out source_nmos source_pmos
M1 net_0 in1 net_1 net_1 pmos
M2 net_2 in2 net_1 net_1 pmos
M3 net_3 net_4 net_0 net_0 pmos
M4 outfirststage net_4 net_2 net_2 pmos
M5 net_3 net_3 source_nmos source_nmos nmos
M6 outfirststage net_3 source_nmos source_nmos nmos
M7 net_5 net_5 source_pmos source_pmos pmos
M8 net_1 net_6 net_5 net_5 pmos
M9 net_7 outfirststage source_pmos source_pmos pmos
M10 out bias_p_3 net_7 net_7 pmos
M11 out ibias source_nmos source_nmos nmos
M12 ibias ibias source_nmos source_nmos nmos
M13 net_4 net_4 net_1 net_1 pmos
M14 net_6 net_6 bias_p_2m bias_p_2m pmos
M15 bias_p_2m net_5 source_pmos source_pmos pmos
M16 bias_p_3 bias_p_3 source_pmos source_pmos pmos
M17 net_6 ibias source_nmos source_nmos nmos
M18 net_4 ibias source_nmos source_nmos nmos
M19 bias_p_3 ibias source_nmos source_nmos nmos
Cap_load_1 out source_nmos
Cap_compensation_1 outfirststage out
.end two_stage_single_output_op_amp1198
