.suckt  symmetrical_op_amp95 ibias in1 in2 out source_nmos source_pmos
M1 out1fs in1 net_0 net_0 pmos
M2 insourcetc in2 net_0 net_0 pmos
M3 net_1 out1fs source_nmos source_nmos nmos
M4 out1fs bias_n_1 net_1 net_1 nmos
M5 net_2 insourcetc source_nmos source_nmos nmos
M6 insourcetc bias_n_1 net_2 net_2 nmos
M7 net_0 ibias source_pmos source_pmos pmos
M8 net_4 insourcestagebias source_pmos source_pmos pmos
M9 out bias_p_2 net_4 net_4 pmos
M10 net_5 out1fs source_nmos source_nmos nmos
M11 out bias_n_1 net_5 net_5 nmos
M12 net_6 insourcetc source_nmos source_nmos nmos
M13 insourcestagebias bias_n_1 net_6 net_6 nmos
M14 net_7 insourcestagebias source_pmos source_pmos pmos
M15 insourcestagebias bias_p_2 net_7 net_7 pmos
M16 bias_n_1 bias_n_1 source_nmos source_nmos nmos
M17 bias_p_2 bias_p_2 source_pmos source_pmos pmos
M18 ibias ibias source_pmos source_pmos pmos
M19 bias_n_4 bias_n_4 source_nmos source_nmos nmos
M20 bias_n_1 ibias source_pmos source_pmos pmos
M21 bias_p_2 bias_n_4 source_nmos source_nmos nmos
M22 bias_n_4 ibias source_pmos source_pmos pmos
Cap_load_1 out source_nmos
.end symmetrical_op_amp95
