.suckt  symmetrical_op_amp144 ibias in1 in2 out source_nmos source_pmos
M1 out1fs in1 net_0 net_0 pmos
M2 insourcetc in2 net_0 net_0 pmos
M3 net_1 out1fs source_nmos source_nmos nmos
M4 out1fs bias_n_1 net_1 net_1 nmos
M5 net_2 insourcetc source_nmos source_nmos nmos
M6 insourcetc bias_n_1 net_2 net_2 nmos
M7 net_3 ibias source_pmos source_pmos pmos
M8 net_0 bias_p_2 net_3 net_3 pmos
M9 net_6 insourcestagebias source_pmos source_pmos pmos
M10 out bias_p_2 net_6 net_6 pmos
M11 net_7 out1fs source_nmos source_nmos nmos
M12 out bias_n_1 net_7 net_7 nmos
M13 net_8 insourcetc source_nmos source_nmos nmos
M14 insourcestagebias bias_n_1 net_8 net_8 nmos
M15 net_9 insourcestagebias source_pmos source_pmos pmos
M16 insourcestagebias bias_p_2 net_9 net_9 pmos
M17 bias_n_1 bias_n_1 source_nmos source_nmos nmos
M18 bias_p_2 bias_p_2 source_pmos source_pmos pmos
M19 ibias ibias source_pmos source_pmos pmos
M20 bias_n_4 bias_n_4 source_nmos source_nmos nmos
M21 bias_n_1 ibias source_pmos source_pmos pmos
M22 bias_p_2 bias_n_4 source_nmos source_nmos nmos
M23 bias_n_4 ibias source_pmos source_pmos pmos
Cap_load_1 out source_nmos
.end symmetrical_op_amp144
