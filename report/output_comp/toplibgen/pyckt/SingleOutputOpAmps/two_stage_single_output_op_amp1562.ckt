.suckt  two_stage_single_output_op_amp1562 ibias in1 in2 out source_nmos source_pmos
M1 net_0 in1 net_1 net_1 pmos
M2 outfirststage in2 net_1 net_1 pmos
M3 net_0 net_0 source_pmos source_pmos pmos
M4 net_2 net_0 source_pmos source_pmos pmos
M5 outfirststage bias_p_3 net_2 net_2 pmos
M6 net_0 bias_n_2 source_nmos source_nmos nmos
M7 outfirststage bias_n_2 source_nmos source_nmos nmos
M8 net_1 ibias source_pmos source_pmos pmos
M9 out ibias source_pmos source_pmos pmos
M10 net_7 outfirststage source_nmos source_nmos nmos
M11 out bias_n_1 net_7 net_7 nmos
M12 bias_n_1 bias_n_1 source_nmos source_nmos nmos
M13 bias_n_2 bias_n_2 source_nmos source_nmos nmos
M14 bias_p_3 bias_p_3 source_pmos source_pmos pmos
M15 ibias ibias source_pmos source_pmos pmos
M16 bias_n_2 ibias source_pmos source_pmos pmos
M17 bias_n_1 ibias source_pmos source_pmos pmos
M18 bias_p_3 bias_n_2 source_nmos source_nmos nmos
Cap_load_1 out source_nmos
Cap_compensation_1 outfirststage out
.end two_stage_single_output_op_amp1562
