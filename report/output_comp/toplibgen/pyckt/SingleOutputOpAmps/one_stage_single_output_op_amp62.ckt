.suckt  one_stage_single_output_op_amp62 ibias in1 in2 out source_nmos source_pmos
M1 net_0 in1 net_1 net_1 pmos
M2 net_2 in2 net_1 net_1 pmos
M3 net_0 bias_n_1b source_nmos source_nmos nmos
M4 net_4 ibias net_0 net_0 nmos
M5 net_2 bias_n_1b source_nmos source_nmos nmos
M6 out ibias net_2 net_2 nmos
M7 net_4 net_4 source_pmos source_pmos pmos
M8 net_6 net_4 source_pmos source_pmos pmos
M9 out bias_p_3 net_6 net_6 pmos
M10 net_8 net_8 source_pmos source_pmos pmos
M11 net_1 net_9 net_8 net_8 pmos
M12 bias_n_1b bias_n_1b source_nmos source_nmos nmos
M13 ibias ibias bias_n_1b bias_n_1b nmos
M14 net_9 net_9 bias_p_2m bias_p_2m pmos
M15 bias_p_2m net_8 source_pmos source_pmos pmos
M16 bias_p_3 bias_p_3 source_pmos source_pmos pmos
M17 net_9 bias_n_1b source_nmos source_nmos nmos
M18 bias_p_3 bias_n_1b source_nmos source_nmos nmos
Cap_load_1 out source_nmos
.end one_stage_single_output_op_amp62
