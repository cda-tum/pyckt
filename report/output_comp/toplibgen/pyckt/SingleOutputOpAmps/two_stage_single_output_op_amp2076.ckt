.suckt  two_stage_single_output_op_amp2076 ibias in1 in2 out source_nmos source_pmos
M1 net_0 in1 net_1 net_1 pmos
M2 outfirststage in2 net_1 net_1 pmos
M3 net_2 net_0 source_pmos source_pmos pmos
M4 net_0 bias_p_3 net_2 net_2 pmos
M5 net_4 net_0 source_pmos source_pmos pmos
M6 outfirststage bias_p_3 net_4 net_4 pmos
M7 net_5 bias_n_2b source_nmos source_nmos nmos
M8 net_0 bias_n_2t net_5 net_5 nmos
M9 net_8 bias_n_2b source_nmos source_nmos nmos
M10 outfirststage bias_n_2t net_8 net_8 nmos
M11 net_9 ibias source_pmos source_pmos pmos
M12 net_1 bias_p_3 net_9 net_9 pmos
M13 net_12 outfirststage source_pmos source_pmos pmos
M14 out bias_p_3 net_12 net_12 pmos
M15 net_14 net_14 source_nmos source_nmos nmos
M16 out net_15 net_14 net_14 nmos
M17 net_15 net_15 bias_n_1m bias_n_1m nmos
M18 bias_n_1m net_14 source_nmos source_nmos nmos
M19 bias_n_2b bias_n_2b source_nmos source_nmos nmos
M20 bias_n_2t bias_n_2t bias_n_2b bias_n_2b nmos
M21 bias_p_3 bias_p_3 source_pmos source_pmos pmos
M22 ibias ibias source_pmos source_pmos pmos
M23 bias_n_2t ibias source_pmos source_pmos pmos
M24 bias_p_3 bias_n_2b source_nmos source_nmos nmos
M25 net_15 ibias source_pmos source_pmos pmos
Cap_load_1 out source_nmos
Cap_compensation_1 outfirststage out
.end two_stage_single_output_op_amp2076
