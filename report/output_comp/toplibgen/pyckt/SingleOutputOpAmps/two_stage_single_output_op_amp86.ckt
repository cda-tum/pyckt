.suckt  two_stage_single_output_op_amp86 ibias in1 in2 out source_nmos source_pmos
M1 net_0 in1 net_1 net_1 nmos
M2 outfirststage in2 net_1 net_1 nmos
M3 net_0 net_0 source_pmos source_pmos pmos
M4 outfirststage net_0 source_pmos source_pmos pmos
M5 net_1 bias_n_2 source_nmos source_nmos nmos
M6 out ibias source_pmos source_pmos pmos
M7 net_4 outfirststage source_nmos source_nmos nmos
M8 out bias_n_1 net_4 net_4 nmos
M9 bias_n_1 bias_n_1 source_nmos source_nmos nmos
M10 bias_n_2 bias_n_2 source_nmos source_nmos nmos
M11 ibias ibias source_pmos source_pmos pmos
M12 bias_n_2 ibias source_pmos source_pmos pmos
M13 bias_n_1 ibias source_pmos source_pmos pmos
Cap_load_1 out source_nmos
Cap_compensation_1 outfirststage out
.end two_stage_single_output_op_amp86
