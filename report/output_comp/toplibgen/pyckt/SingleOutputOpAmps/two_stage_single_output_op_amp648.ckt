.suckt  two_stage_single_output_op_amp648 ibias in1 in2 out source_nmos source_pmos
M1 net_0 in1 net_1 net_1 nmos
M2 net_2 in2 net_1 net_1 nmos
M3 net_0 ibias source_pmos source_pmos pmos
M4 net_4 bias_p_4 net_0 net_0 pmos
M5 net_2 ibias source_pmos source_pmos pmos
M6 outfirststage bias_p_4 net_2 net_2 pmos
M7 net_6 net_4 source_nmos source_nmos nmos
M8 net_4 bias_n_2 net_6 net_6 nmos
M9 net_8 net_4 source_nmos source_nmos nmos
M10 outfirststage bias_n_2 net_8 net_8 nmos
M11 net_1 bias_n_3 source_nmos source_nmos nmos
M12 net_10 outfirststage source_pmos source_pmos pmos
M13 out bias_p_4 net_10 net_10 pmos
M14 net_12 net_12 source_nmos source_nmos nmos
M15 out net_13 net_12 net_12 nmos
M16 net_13 net_13 bias_n_1m bias_n_1m nmos
M17 bias_n_1m net_12 source_nmos source_nmos nmos
M18 bias_n_2 bias_n_2 source_nmos source_nmos nmos
M19 bias_n_3 bias_n_3 source_nmos source_nmos nmos
M20 bias_p_4 bias_p_4 source_pmos source_pmos pmos
M21 ibias ibias source_pmos source_pmos pmos
M22 bias_n_3 ibias source_pmos source_pmos pmos
M23 bias_n_2 ibias source_pmos source_pmos pmos
M24 bias_p_4 bias_n_3 source_nmos source_nmos nmos
M25 net_13 ibias source_pmos source_pmos pmos
Cap_load_1 out source_nmos
Cap_compensation_1 outfirststage out
.end two_stage_single_output_op_amp648
