.suckt  symmetrical_op_amp147 ibias in1 in2 out source_nmos source_pmos
M1 out1fs in1 net_0 net_0 pmos
M2 insourcetc in2 net_0 net_0 pmos
M3 net_1 out1fs source_nmos source_nmos nmos
M4 out1fs bias_n_1 net_1 net_1 nmos
M5 net_2 insourcetc source_nmos source_nmos nmos
M6 insourcetc bias_n_1 net_2 net_2 nmos
M7 net_3 bias_p_2b source_pmos source_pmos pmos
M8 net_0 ibias net_3 net_3 pmos
M9 insourcestagebias insourcestagebias source_pmos source_pmos pmos
M10 out inoutputstagebias insourcestagebias insourcestagebias pmos
M11 net_6 out1fs source_nmos source_nmos nmos
M12 out bias_n_1 net_6 net_6 nmos
M13 net_7 insourcetc source_nmos source_nmos nmos
M14 inoutputstagebias bias_n_1 net_7 net_7 nmos
M15 net_8 insourcestagebias source_pmos source_pmos pmos
M16 inoutputstagebias inoutputstagebias net_8 net_8 pmos
M17 bias_n_1 bias_n_1 source_nmos source_nmos nmos
M18 bias_p_2b bias_p_2b source_pmos source_pmos pmos
M19 ibias ibias bias_p_2b bias_p_2b pmos
M20 bias_n_1 bias_p_2b source_pmos source_pmos pmos
Cap_load_1 out source_nmos
.end symmetrical_op_amp147
