.suckt  symmetrical_op_amp110 ibias in1 in2 out source_nmos source_pmos
M1 out2fs in1 net_0 net_0 nmos
M2 inoutputtc in2 net_0 net_0 nmos
M3 out1fs out1fs source_pmos source_pmos pmos
M4 out2fs out2fs out1fs out1fs pmos
M5 insourcetc insourcetc source_pmos source_pmos pmos
M6 inoutputtc inoutputtc insourcetc insourcetc pmos
M7 net_0 ibias source_nmos source_nmos nmos
M8 net_2 out1fs source_pmos source_pmos pmos
M9 out out2fs net_2 net_2 pmos
M10 net_3 inoutputstagebias source_nmos source_nmos nmos
M11 out inoutputstagebias net_3 net_3 nmos
M12 net_4 insourcetc source_pmos source_pmos pmos
M13 inoutputstagebias inoutputtc net_4 net_4 pmos
M14 net_5 inoutputstagebias source_nmos source_nmos nmos
M15 inoutputstagebias inoutputstagebias net_5 net_5 nmos
M16 ibias ibias source_nmos source_nmos nmos
Cap_load_1 out source_nmos
.end symmetrical_op_amp110
