.suckt  two_stage_single_output_op_amp1105 ibias in1 in2 out source_nmos source_pmos
M1 net_0 in1 net_1 net_1 nmos
M2 net_2 in2 net_1 net_1 nmos
M3 net_3 net_4 net_0 net_0 nmos
M4 outfirststage net_4 net_2 net_2 nmos
M5 net_3 net_5 source_pmos source_pmos pmos
M6 net_5 net_5 source_pmos source_pmos pmos
M7 outfirststage net_3 net_5 net_5 pmos
M8 net_1 bias_n_1 source_nmos source_nmos nmos
M9 out ibias source_pmos source_pmos pmos
M10 out outfirststage source_nmos source_nmos nmos
M11 net_4 net_4 net_1 net_1 nmos
M12 bias_n_1 bias_n_1 source_nmos source_nmos nmos
M13 ibias ibias source_pmos source_pmos pmos
M14 bias_n_1 ibias source_pmos source_pmos pmos
M15 net_4 ibias source_pmos source_pmos pmos
Cap_load_1 out source_nmos
Cap_compensation_1 outfirststage out
.end two_stage_single_output_op_amp1105
