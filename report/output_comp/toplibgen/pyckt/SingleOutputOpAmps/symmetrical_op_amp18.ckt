.suckt  symmetrical_op_amp18 ibias in1 in2 out source_nmos source_pmos
M1 out1fs in1 net_0 net_0 nmos
M2 out2fs in2 net_0 net_0 nmos
M3 out1fs out1fs source_pmos source_pmos pmos
M4 out2fs out2fs source_pmos source_pmos pmos
M5 net_0 ibias source_nmos source_nmos nmos
M6 out out1fs source_pmos source_pmos pmos
M7 net_2 insourcestagebias source_nmos source_nmos nmos
M8 out bias_n_1 net_2 net_2 nmos
M9 insourcestagebias out2fs source_pmos source_pmos pmos
M10 net_3 insourcestagebias source_nmos source_nmos nmos
M11 insourcestagebias bias_n_1 net_3 net_3 nmos
M12 bias_n_1 bias_n_1 source_nmos source_nmos nmos
M13 ibias ibias source_nmos source_nmos nmos
M14 bias_p_3 bias_p_3 source_pmos source_pmos pmos
M15 bias_n_1 bias_p_3 source_pmos source_pmos pmos
M16 bias_p_3 ibias source_nmos source_nmos nmos
Cap_load_1 out source_nmos
.end symmetrical_op_amp18
