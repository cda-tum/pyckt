.suckt  two_stage_single_output_op_amp224 ibias in1 in2 out source_nmos source_pmos
M1 net_0 in1 net_1 net_1 pmos
M2 outfirststage in2 net_1 net_1 pmos
M3 net_0 net_0 source_nmos source_nmos nmos
M4 net_2 net_0 source_nmos source_nmos nmos
M5 outfirststage bias_n_1 net_2 net_2 nmos
M6 net_4 bias_p_3b source_pmos source_pmos pmos
M7 net_1 ibias net_4 net_4 pmos
M8 out outfirststage source_pmos source_pmos pmos
M9 net_7 bias_n_2 source_nmos source_nmos nmos
M10 out bias_n_1 net_7 net_7 nmos
M11 bias_n_1 bias_n_1 source_nmos source_nmos nmos
M12 bias_n_2 bias_n_2 source_nmos source_nmos nmos
M13 bias_p_3b bias_p_3b source_pmos source_pmos pmos
M14 ibias ibias bias_p_3b bias_p_3b pmos
M15 bias_n_2 bias_p_3b source_pmos source_pmos pmos
M16 bias_n_1 bias_p_3b source_pmos source_pmos pmos
Cap_load_1 out source_nmos
Cap_compensation_1 outfirststage out
.end two_stage_single_output_op_amp224
