.suckt  two_stage_single_output_op_amp54 ibias in1 in2 out source_nmos source_pmos
M1 net_0 in1 net_1 net_1 pmos
M2 outfirststage in2 net_1 net_1 pmos
M3 net_2 net_0 source_nmos source_nmos nmos
M4 net_0 bias_n_1 net_2 net_2 nmos
M5 net_4 net_0 source_nmos source_nmos nmos
M6 outfirststage bias_n_1 net_4 net_4 nmos
M7 net_1 ibias source_pmos source_pmos pmos
M8 net_6 net_6 source_pmos source_pmos pmos
M9 out net_7 net_6 net_6 pmos
M10 net_8 outfirststage source_nmos source_nmos nmos
M11 out bias_n_1 net_8 net_8 nmos
M12 bias_n_1 bias_n_1 source_nmos source_nmos nmos
M13 net_7 net_7 bias_p_2m bias_p_2m pmos
M14 bias_p_2m net_6 source_pmos source_pmos pmos
M15 ibias ibias source_pmos source_pmos pmos
M16 bias_n_4 bias_n_4 source_nmos source_nmos nmos
M17 bias_n_1 ibias source_pmos source_pmos pmos
M18 net_7 bias_n_4 source_nmos source_nmos nmos
M19 bias_n_4 ibias source_pmos source_pmos pmos
Cap_load_1 out source_nmos
Cap_compensation_1 outfirststage out
.end two_stage_single_output_op_amp54
