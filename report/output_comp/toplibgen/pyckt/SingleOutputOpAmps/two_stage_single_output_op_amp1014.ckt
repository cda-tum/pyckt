.suckt  two_stage_single_output_op_amp1014 ibias in1 in2 out source_nmos source_pmos
M1 net_0 in1 net_1 net_1 pmos
M2 net_2 in2 net_1 net_1 pmos
M3 net_3 net_4 net_0 net_0 pmos
M4 outfirststage net_4 net_2 net_2 pmos
M5 net_3 net_3 source_nmos source_nmos nmos
M6 outfirststage net_3 source_nmos source_nmos nmos
M7 net_1 ibias source_pmos source_pmos pmos
M8 net_6 net_6 source_pmos source_pmos pmos
M9 out net_7 net_6 net_6 pmos
M10 net_8 outfirststage source_nmos source_nmos nmos
M11 out bias_n_1 net_8 net_8 nmos
M12 bias_n_1 bias_n_1 source_nmos source_nmos nmos
M13 net_4 net_4 net_1 net_1 pmos
M14 net_7 net_7 bias_p_2m bias_p_2m pmos
M15 bias_p_2m net_6 source_pmos source_pmos pmos
M16 ibias ibias source_pmos source_pmos pmos
M17 bias_n_4 bias_n_4 source_nmos source_nmos nmos
M18 bias_n_1 ibias source_pmos source_pmos pmos
M19 net_4 bias_n_4 source_nmos source_nmos nmos
M20 net_7 bias_n_4 source_nmos source_nmos nmos
M21 bias_n_4 ibias source_pmos source_pmos pmos
Cap_load_1 out source_nmos
Cap_compensation_1 outfirststage out
.end two_stage_single_output_op_amp1014
