.suckt  two_stage_single_output_op_amp1351 ibias in1 in2 out source_nmos source_pmos
M1 net_0 in1 net_1 net_1 nmos
M2 net_2 in2 net_1 net_1 nmos
M3 net_3 net_4 net_0 net_0 nmos
M4 outfirststage net_4 net_2 net_2 nmos
M5 net_3 net_3 source_pmos source_pmos pmos
M6 outfirststage net_3 source_pmos source_pmos pmos
M7 net_5 ibias source_nmos source_nmos nmos
M8 net_1 bias_n_1 net_5 net_5 nmos
M9 out outfirststage source_pmos source_pmos pmos
M10 out ibias source_nmos source_nmos nmos
M11 net_4 net_4 net_1 net_1 nmos
M12 bias_n_1 bias_n_1 source_nmos source_nmos nmos
M13 ibias ibias source_nmos source_nmos nmos
M14 bias_p_3 bias_p_3 source_pmos source_pmos pmos
M15 net_4 bias_p_3 source_pmos source_pmos pmos
M16 bias_n_1 bias_p_3 source_pmos source_pmos pmos
M17 bias_p_3 ibias source_nmos source_nmos nmos
Cap_load_1 out source_nmos
Cap_compensation_1 outfirststage out
.end two_stage_single_output_op_amp1351
