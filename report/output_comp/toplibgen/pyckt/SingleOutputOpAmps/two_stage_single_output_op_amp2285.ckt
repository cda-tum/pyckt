.suckt  two_stage_single_output_op_amp2285 ibias in1 in2 out source_nmos source_pmos
M1 net_0 in1 net_1 net_1 nmos
M2 outfirststage in2 net_1 net_1 nmos
M3 net_0 net_0 source_nmos source_nmos nmos
M4 net_2 net_0 source_nmos source_nmos nmos
M5 outfirststage bias_n_1 net_2 net_2 nmos
M6 net_0 bias_p_4 source_pmos source_pmos pmos
M7 outfirststage bias_p_4 source_pmos source_pmos pmos
M8 net_5 ibias source_nmos source_nmos nmos
M9 net_1 bias_n_1 net_5 net_5 nmos
M10 net_8 net_8 source_pmos source_pmos pmos
M11 out net_9 net_8 net_8 pmos
M12 out outfirststage source_nmos source_nmos nmos
M13 bias_n_1 bias_n_1 source_nmos source_nmos nmos
M14 ibias ibias source_nmos source_nmos nmos
M15 net_9 net_9 bias_p_3m bias_p_3m pmos
M16 bias_p_3m net_8 source_pmos source_pmos pmos
M17 bias_p_4 bias_p_4 source_pmos source_pmos pmos
M18 bias_p_4 ibias source_nmos source_nmos nmos
M19 bias_n_1 bias_p_4 source_pmos source_pmos pmos
M20 net_9 ibias source_nmos source_nmos nmos
Cap_load_1 out source_nmos
Cap_compensation_1 outfirststage out
.end two_stage_single_output_op_amp2285
