.suckt  two_stage_single_output_op_amp1722 ibias in1 in2 out source_nmos source_pmos
M1 net_0 in1 net_1 net_1 nmos
M2 outfirststage in2 net_1 net_1 nmos
M3 net_0 net_2 source_nmos source_nmos nmos
M4 net_2 net_2 source_nmos source_nmos nmos
M5 outfirststage net_0 net_2 net_2 nmos
M6 net_3 bias_p_4b source_pmos source_pmos pmos
M7 net_0 bias_p_4t net_3 net_3 pmos
M8 net_6 bias_p_4b source_pmos source_pmos pmos
M9 outfirststage bias_p_4t net_6 net_6 pmos
M10 net_1 ibias source_nmos source_nmos nmos
M11 net_8 net_8 source_pmos source_pmos pmos
M12 out net_9 net_8 net_8 pmos
M13 net_10 outfirststage source_nmos source_nmos nmos
M14 out bias_n_1 net_10 net_10 nmos
M15 bias_n_1 bias_n_1 source_nmos source_nmos nmos
M16 ibias ibias source_nmos source_nmos nmos
M17 net_9 net_9 bias_p_3m bias_p_3m pmos
M18 bias_p_3m net_8 source_pmos source_pmos pmos
M19 bias_p_4b bias_p_4b source_pmos source_pmos pmos
M20 bias_p_4t bias_p_4t bias_p_4b bias_p_4b pmos
M21 bias_p_4t ibias source_nmos source_nmos nmos
M22 bias_n_1 bias_p_4b source_pmos source_pmos pmos
M23 net_9 ibias source_nmos source_nmos nmos
Cap_load_1 out source_nmos
Cap_compensation_1 outfirststage out
.end two_stage_single_output_op_amp1722
