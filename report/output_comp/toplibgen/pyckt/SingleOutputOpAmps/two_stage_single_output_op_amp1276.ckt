.suckt  two_stage_single_output_op_amp1276 ibias in1 in2 out source_nmos source_pmos
M1 net_0 in1 net_1 net_1 pmos
M2 net_2 in2 net_1 net_1 pmos
M3 net_3 net_4 net_0 net_0 pmos
M4 outfirststage net_4 net_2 net_2 pmos
M5 net_5 net_3 source_nmos source_nmos nmos
M6 net_3 bias_n_1 net_5 net_5 nmos
M7 net_7 net_3 source_nmos source_nmos nmos
M8 outfirststage bias_n_1 net_7 net_7 nmos
M9 net_8 bias_p_2b source_pmos source_pmos pmos
M10 net_1 ibias net_8 net_8 pmos
M11 net_11 bias_p_2b source_pmos source_pmos pmos
M12 out ibias net_11 net_11 pmos
M13 net_14 outfirststage source_nmos source_nmos nmos
M14 out bias_n_1 net_14 net_14 nmos
M15 bias_n_1 bias_n_1 source_nmos source_nmos nmos
M16 net_4 net_4 net_1 net_1 pmos
M17 bias_p_2b bias_p_2b source_pmos source_pmos pmos
M18 ibias ibias bias_p_2b bias_p_2b pmos
M19 bias_n_3 bias_n_3 source_nmos source_nmos nmos
M20 bias_n_1 bias_p_2b source_pmos source_pmos pmos
M21 net_4 bias_n_3 source_nmos source_nmos nmos
M22 bias_n_3 bias_p_2b source_pmos source_pmos pmos
Cap_load_1 out source_nmos
Cap_compensation_1 outfirststage out
.end two_stage_single_output_op_amp1276
