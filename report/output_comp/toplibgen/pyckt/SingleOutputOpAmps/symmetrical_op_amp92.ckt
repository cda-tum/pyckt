.suckt  symmetrical_op_amp92 ibias in1 in2 out source_nmos source_pmos
M1 out1fs in1 net_0 net_0 pmos
M2 insourcetc in2 net_0 net_0 pmos
M3 net_1 out1fs source_nmos source_nmos nmos
M4 out1fs bias_n_1 net_1 net_1 nmos
M5 net_2 insourcetc source_nmos source_nmos nmos
M6 insourcetc bias_n_1 net_2 net_2 nmos
M7 net_0 ibias source_pmos source_pmos pmos
M8 out instagebias source_pmos source_pmos pmos
M9 net_4 out1fs source_nmos source_nmos nmos
M10 out bias_n_1 net_4 net_4 nmos
M11 net_5 insourcetc source_nmos source_nmos nmos
M12 instagebias bias_n_1 net_5 net_5 nmos
M13 instagebias instagebias source_pmos source_pmos pmos
M14 bias_n_1 bias_n_1 source_nmos source_nmos nmos
M15 ibias ibias source_pmos source_pmos pmos
M16 bias_n_1 ibias source_pmos source_pmos pmos
Cap_load_1 out source_nmos
.end symmetrical_op_amp92
