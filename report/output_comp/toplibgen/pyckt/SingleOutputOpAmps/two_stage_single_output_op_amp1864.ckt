.suckt  two_stage_single_output_op_amp1864 ibias in1 in2 out source_nmos source_pmos
M1 net_0 in1 net_1 net_1 pmos
M2 outfirststage in2 net_1 net_1 pmos
M3 net_0 net_0 source_pmos source_pmos pmos
M4 outfirststage net_0 source_pmos source_pmos pmos
M5 net_0 bias_n_2 source_nmos source_nmos nmos
M6 outfirststage bias_n_2 source_nmos source_nmos nmos
M7 net_3 net_3 source_pmos source_pmos pmos
M8 net_1 net_4 net_3 net_3 pmos
M9 net_5 bias_p_4b source_pmos source_pmos pmos
M10 out ibias net_5 net_5 pmos
M11 net_8 outfirststage source_nmos source_nmos nmos
M12 out bias_n_1 net_8 net_8 nmos
M13 bias_n_1 bias_n_1 source_nmos source_nmos nmos
M14 bias_n_2 bias_n_2 source_nmos source_nmos nmos
M15 net_4 net_4 bias_p_3m bias_p_3m pmos
M16 bias_p_3m net_3 source_pmos source_pmos pmos
M17 bias_p_4b bias_p_4b source_pmos source_pmos pmos
M18 ibias ibias bias_p_4b bias_p_4b pmos
M19 bias_n_2 bias_p_4b source_pmos source_pmos pmos
M20 bias_n_1 bias_p_4b source_pmos source_pmos pmos
M21 net_4 bias_n_2 source_nmos source_nmos nmos
Cap_load_1 out source_nmos
Cap_compensation_1 outfirststage out
.end two_stage_single_output_op_amp1864
