.suckt  one_stage_single_output_op_amp38 ibias in1 in2 out source_nmos source_pmos
M1 net_0 in1 net_1 net_1 nmos
M2 out in2 net_1 net_1 nmos
M3 net_2 net_0 source_pmos source_pmos pmos
M4 net_0 bias_p_2 net_2 net_2 pmos
M5 net_4 net_0 source_pmos source_pmos pmos
M6 out bias_p_2 net_4 net_4 pmos
M7 net_5 net_5 source_nmos source_nmos nmos
M8 net_1 ibias net_5 net_5 nmos
M9 ibias ibias bias_n_1m bias_n_1m nmos
M10 bias_n_1m net_5 source_nmos source_nmos nmos
M11 bias_p_2 bias_p_2 source_pmos source_pmos pmos
M12 bias_p_2 net_5 source_nmos source_nmos nmos
Cap_load_1 out source_nmos
.end one_stage_single_output_op_amp38
