.suckt  two_stage_single_output_op_amp864 ibias in1 in2 out source_nmos source_pmos
M1 net_0 in1 net_1 net_1 nmos
M2 net_2 in2 net_1 net_1 nmos
M3 net_0 bias_p_4 source_pmos source_pmos pmos
M4 net_4 bias_p_3 net_0 net_0 pmos
M5 net_2 bias_p_4 source_pmos source_pmos pmos
M6 outfirststage bias_p_3 net_2 net_2 pmos
M7 net_4 net_4 source_nmos source_nmos nmos
M8 outfirststage net_4 source_nmos source_nmos nmos
M9 net_6 net_6 source_nmos source_nmos nmos
M10 net_1 net_7 net_6 net_6 nmos
M11 net_8 outfirststage source_pmos source_pmos pmos
M12 out bias_p_3 net_8 net_8 pmos
M13 net_10 net_10 source_nmos source_nmos nmos
M14 out ibias net_10 net_10 nmos
M15 net_7 net_7 bias_n_1m bias_n_1m nmos
M16 bias_n_1m net_6 source_nmos source_nmos nmos
M17 ibias ibias bias_n_2m bias_n_2m nmos
M18 bias_n_2m net_10 source_nmos source_nmos nmos
M19 bias_p_3 bias_p_3 source_pmos source_pmos pmos
M20 bias_p_4 bias_p_4 source_pmos source_pmos pmos
M21 bias_p_4 net_10 source_nmos source_nmos nmos
M22 bias_p_3 net_10 source_nmos source_nmos nmos
M23 net_7 bias_p_4 source_pmos source_pmos pmos
Cap_load_1 out source_nmos
Cap_compensation_1 outfirststage out
.end two_stage_single_output_op_amp864
