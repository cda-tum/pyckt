.suckt  two_stage_single_output_op_amp1800 ibias in1 in2 out source_nmos source_pmos
M1 net_0 in1 net_1 net_1 nmos
M2 outfirststage in2 net_1 net_1 nmos
M3 net_2 net_0 source_nmos source_nmos nmos
M4 net_0 bias_n_2 net_2 net_2 nmos
M5 net_4 net_0 source_nmos source_nmos nmos
M6 outfirststage bias_n_2 net_4 net_4 nmos
M7 net_5 ibias source_pmos source_pmos pmos
M8 net_0 bias_p_4 net_5 net_5 pmos
M9 net_8 ibias source_pmos source_pmos pmos
M10 outfirststage bias_p_4 net_8 net_8 pmos
M11 net_1 bias_n_3 source_nmos source_nmos nmos
M12 net_10 outfirststage source_pmos source_pmos pmos
M13 out bias_p_4 net_10 net_10 pmos
M14 net_12 net_12 source_nmos source_nmos nmos
M15 out net_13 net_12 net_12 nmos
M16 net_13 net_13 bias_n_1m bias_n_1m nmos
M17 bias_n_1m net_12 source_nmos source_nmos nmos
M18 bias_n_2 bias_n_2 source_nmos source_nmos nmos
M19 bias_n_3 bias_n_3 source_nmos source_nmos nmos
M20 bias_p_4 bias_p_4 source_pmos source_pmos pmos
M21 ibias ibias source_pmos source_pmos pmos
M22 bias_n_3 ibias source_pmos source_pmos pmos
M23 bias_n_2 ibias source_pmos source_pmos pmos
M24 bias_p_4 bias_n_3 source_nmos source_nmos nmos
M25 net_13 ibias source_pmos source_pmos pmos
Cap_load_1 out source_nmos
Cap_compensation_1 outfirststage out
.end two_stage_single_output_op_amp1800
