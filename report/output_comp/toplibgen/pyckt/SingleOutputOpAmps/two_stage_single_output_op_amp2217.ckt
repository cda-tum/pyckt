.suckt  two_stage_single_output_op_amp2217 ibias in1 in2 out source_nmos source_pmos
M1 net_0 in1 net_1 net_1 nmos
M2 outfirststage in2 net_1 net_1 nmos
M3 net_0 net_0 source_nmos source_nmos nmos
M4 outfirststage net_0 source_nmos source_nmos nmos
M5 net_2 bias_p_3b source_pmos source_pmos pmos
M6 net_0 ibias net_2 net_2 pmos
M7 net_5 bias_p_3b source_pmos source_pmos pmos
M8 outfirststage ibias net_5 net_5 pmos
M9 net_6 bias_n_2b source_nmos source_nmos nmos
M10 net_1 bias_n_2t net_6 net_6 nmos
M11 out outfirststage source_pmos source_pmos pmos
M12 net_9 net_9 source_nmos source_nmos nmos
M13 out net_10 net_9 net_9 nmos
M14 net_10 net_10 bias_n_1m bias_n_1m nmos
M15 bias_n_1m net_9 source_nmos source_nmos nmos
M16 bias_n_2b bias_n_2b source_nmos source_nmos nmos
M17 bias_n_2t bias_n_2t bias_n_2b bias_n_2b nmos
M18 bias_p_3b bias_p_3b source_pmos source_pmos pmos
M19 ibias ibias bias_p_3b bias_p_3b pmos
M20 bias_n_2t bias_p_3b source_pmos source_pmos pmos
M21 net_10 bias_p_3b source_pmos source_pmos pmos
Cap_load_1 out source_nmos
Cap_compensation_1 outfirststage out
.end two_stage_single_output_op_amp2217
