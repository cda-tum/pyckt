.suckt  two_stage_single_output_op_amp2292 ibias in1 in2 out source_nmos source_pmos
M1 net_0 in1 net_1 net_1 nmos
M2 outfirststage in2 net_1 net_1 nmos
M3 net_0 net_0 source_nmos source_nmos nmos
M4 net_2 net_0 source_nmos source_nmos nmos
M5 outfirststage bias_n_2 net_2 net_2 nmos
M6 net_0 ibias source_pmos source_pmos pmos
M7 outfirststage ibias source_pmos source_pmos pmos
M8 net_5 bias_n_3 source_nmos source_nmos nmos
M9 net_1 bias_n_2 net_5 net_5 nmos
M10 net_8 outfirststage source_pmos source_pmos pmos
M11 out bias_p_4 net_8 net_8 pmos
M12 net_10 net_10 source_nmos source_nmos nmos
M13 out net_11 net_10 net_10 nmos
M14 net_11 net_11 bias_n_1m bias_n_1m nmos
M15 bias_n_1m net_10 source_nmos source_nmos nmos
M16 bias_n_2 bias_n_2 source_nmos source_nmos nmos
M17 bias_n_3 bias_n_3 source_nmos source_nmos nmos
M18 bias_p_4 bias_p_4 source_pmos source_pmos pmos
M19 ibias ibias source_pmos source_pmos pmos
M20 bias_n_3 ibias source_pmos source_pmos pmos
M21 bias_n_2 ibias source_pmos source_pmos pmos
M22 bias_p_4 bias_n_3 source_nmos source_nmos nmos
M23 net_11 ibias source_pmos source_pmos pmos
Cap_load_1 out source_nmos
Cap_compensation_1 outfirststage out
.end two_stage_single_output_op_amp2292
