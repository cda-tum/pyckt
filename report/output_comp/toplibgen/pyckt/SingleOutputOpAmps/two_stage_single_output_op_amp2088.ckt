.suckt  two_stage_single_output_op_amp2088 ibias in1 in2 out source_nmos source_pmos
M1 net_0 in1 net_1 net_1 pmos
M2 outfirststage in2 net_1 net_1 pmos
M3 net_2 net_0 source_pmos source_pmos pmos
M4 net_0 bias_p_4 net_2 net_2 pmos
M5 net_4 net_0 source_pmos source_pmos pmos
M6 outfirststage bias_p_4 net_4 net_4 pmos
M7 net_5 bias_n_2b source_nmos source_nmos nmos
M8 net_0 bias_n_2t net_5 net_5 nmos
M9 net_8 bias_n_2b source_nmos source_nmos nmos
M10 outfirststage bias_n_2t net_8 net_8 nmos
M11 net_9 net_9 source_pmos source_pmos pmos
M12 net_1 ibias net_9 net_9 pmos
M13 net_11 outfirststage source_pmos source_pmos pmos
M14 out bias_p_4 net_11 net_11 pmos
M15 net_13 net_13 source_nmos source_nmos nmos
M16 out net_14 net_13 net_13 nmos
M17 net_14 net_14 bias_n_1m bias_n_1m nmos
M18 bias_n_1m net_13 source_nmos source_nmos nmos
M19 bias_n_2b bias_n_2b source_nmos source_nmos nmos
M20 bias_n_2t bias_n_2t bias_n_2b bias_n_2b nmos
M21 ibias ibias bias_p_3m bias_p_3m pmos
M22 bias_p_3m net_9 source_pmos source_pmos pmos
M23 bias_p_4 bias_p_4 source_pmos source_pmos pmos
M24 bias_n_2t net_9 source_pmos source_pmos pmos
M25 bias_p_4 bias_n_2b source_nmos source_nmos nmos
M26 net_14 net_9 source_pmos source_pmos pmos
Cap_load_1 out source_nmos
Cap_compensation_1 outfirststage out
.end two_stage_single_output_op_amp2088
