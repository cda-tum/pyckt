.suckt  one_stage_single_output_op_amp24 ibias in1 in2 out source_nmos source_pmos
M1 net_0 in1 net_1 net_1 pmos
M2 out in2 net_1 net_1 pmos
M3 net_2 net_0 source_nmos source_nmos nmos
M4 net_0 bias_n_1 net_2 net_2 nmos
M5 net_4 net_0 source_nmos source_nmos nmos
M6 out bias_n_1 net_4 net_4 nmos
M7 net_5 net_5 source_pmos source_pmos pmos
M8 net_1 ibias net_5 net_5 pmos
M9 bias_n_1 bias_n_1 source_nmos source_nmos nmos
M10 ibias ibias bias_p_2m bias_p_2m pmos
M11 bias_p_2m net_5 source_pmos source_pmos pmos
M12 bias_n_1 net_5 source_pmos source_pmos pmos
Cap_load_1 out source_nmos
.end one_stage_single_output_op_amp24
