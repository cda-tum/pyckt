.suckt  two_stage_single_output_op_amp374 ibias in1 in2 out source_nmos source_pmos
M1 net_0 in1 net_1 net_1 nmos
M2 outfirststage in2 net_1 net_1 nmos
M3 net_0 net_2 source_pmos source_pmos pmos
M4 net_2 net_2 source_pmos source_pmos pmos
M5 outfirststage net_0 net_2 net_2 pmos
M6 net_3 net_3 source_nmos source_nmos nmos
M7 net_1 net_4 net_3 net_3 nmos
M8 out ibias source_pmos source_pmos pmos
M9 net_6 outfirststage source_nmos source_nmos nmos
M10 out bias_n_2 net_6 net_6 nmos
M11 net_4 net_4 bias_n_1m bias_n_1m nmos
M12 bias_n_1m net_3 source_nmos source_nmos nmos
M13 bias_n_2 bias_n_2 source_nmos source_nmos nmos
M14 ibias ibias source_pmos source_pmos pmos
M15 net_4 ibias source_pmos source_pmos pmos
M16 bias_n_2 ibias source_pmos source_pmos pmos
Cap_load_1 out source_nmos
Cap_compensation_1 outfirststage out
.end two_stage_single_output_op_amp374
