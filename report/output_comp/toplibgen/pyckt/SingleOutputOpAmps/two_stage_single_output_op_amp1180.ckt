.suckt  two_stage_single_output_op_amp1180 ibias in1 in2 out source_nmos source_pmos
M1 net_0 in1 net_1 net_1 pmos
M2 net_2 in2 net_1 net_1 pmos
M3 net_3 net_4 net_0 net_0 pmos
M4 outfirststage net_4 net_2 net_2 pmos
M5 net_3 net_3 source_nmos source_nmos nmos
M6 outfirststage net_3 source_nmos source_nmos nmos
M7 net_5 bias_p_2b source_pmos source_pmos pmos
M8 net_1 ibias net_5 net_5 pmos
M9 net_8 bias_p_2b source_pmos source_pmos pmos
M10 out ibias net_8 net_8 pmos
M11 net_11 outfirststage source_nmos source_nmos nmos
M12 out bias_n_1 net_11 net_11 nmos
M13 bias_n_1 bias_n_1 source_nmos source_nmos nmos
M14 net_4 net_4 net_1 net_1 pmos
M15 bias_p_2b bias_p_2b source_pmos source_pmos pmos
M16 ibias ibias bias_p_2b bias_p_2b pmos
M17 bias_n_3 bias_n_3 source_nmos source_nmos nmos
M18 bias_n_1 bias_p_2b source_pmos source_pmos pmos
M19 net_4 bias_n_3 source_nmos source_nmos nmos
M20 bias_n_3 bias_p_2b source_pmos source_pmos pmos
Cap_load_1 out source_nmos
Cap_compensation_1 outfirststage out
.end two_stage_single_output_op_amp1180
