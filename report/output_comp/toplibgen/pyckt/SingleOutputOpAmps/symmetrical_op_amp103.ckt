.suckt  symmetrical_op_amp103 ibias in1 in2 out source_nmos source_pmos
M1 out2fs in1 net_0 net_0 pmos
M2 inoutputtc in2 net_0 net_0 pmos
M3 net_1 out2fs source_nmos source_nmos nmos
M4 out2fs out2fs net_1 net_1 nmos
M5 net_2 inoutputtc source_nmos source_nmos nmos
M6 inoutputtc inoutputtc net_2 net_2 nmos
M7 net_0 ibias source_pmos source_pmos pmos
M8 net_4 inoutputstagebias source_pmos source_pmos pmos
M9 out inoutputstagebias net_4 net_4 pmos
M10 net_5 out2fs source_nmos source_nmos nmos
M11 out out2fs net_5 net_5 nmos
M12 net_6 inoutputtc source_nmos source_nmos nmos
M13 inoutputstagebias inoutputtc net_6 net_6 nmos
M14 net_7 inoutputstagebias source_pmos source_pmos pmos
M15 inoutputstagebias inoutputstagebias net_7 net_7 pmos
M16 ibias ibias source_pmos source_pmos pmos
Cap_load_1 out source_nmos
.end symmetrical_op_amp103
