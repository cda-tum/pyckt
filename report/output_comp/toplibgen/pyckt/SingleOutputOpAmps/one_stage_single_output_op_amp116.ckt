.suckt  one_stage_single_output_op_amp116 ibias in1 in2 out source_nmos source_pmos
M1 net_0 in1 net_1 net_1 nmos
M2 net_2 in2 net_1 net_1 nmos
M3 net_3 net_4 net_0 net_0 nmos
M4 out net_4 net_2 net_2 nmos
M5 net_3 net_5 source_pmos source_pmos pmos
M6 net_5 net_5 source_pmos source_pmos pmos
M7 out net_3 net_5 net_5 pmos
M8 net_6 net_6 source_nmos source_nmos nmos
M9 net_1 ibias net_6 net_6 nmos
M10 net_4 net_4 net_1 net_1 nmos
M11 ibias ibias bias_n_1m bias_n_1m nmos
M12 bias_n_1m net_6 source_nmos source_nmos nmos
M13 bias_p_2 bias_p_2 source_pmos source_pmos pmos
M14 net_4 bias_p_2 source_pmos source_pmos pmos
M15 bias_p_2 net_6 source_nmos source_nmos nmos
Cap_load_1 out source_nmos
.end one_stage_single_output_op_amp116
