.suckt  two_stage_single_output_op_amp708 ibias in1 in2 out source_nmos source_pmos
M1 net_0 in1 net_1 net_1 pmos
M2 net_2 in2 net_1 net_1 pmos
M3 net_0 bias_n_2b source_nmos source_nmos nmos
M4 net_4 bias_n_2t net_0 net_0 nmos
M5 net_2 bias_n_2b source_nmos source_nmos nmos
M6 outfirststage bias_n_2t net_2 net_2 nmos
M7 net_4 net_6 source_pmos source_pmos pmos
M8 net_6 net_6 source_pmos source_pmos pmos
M9 outfirststage net_4 net_6 net_6 pmos
M10 net_7 ibias source_pmos source_pmos pmos
M11 net_1 bias_p_3 net_7 net_7 pmos
M12 net_10 outfirststage source_pmos source_pmos pmos
M13 out bias_p_3 net_10 net_10 pmos
M14 net_12 net_12 source_nmos source_nmos nmos
M15 out net_13 net_12 net_12 nmos
M16 net_13 net_13 bias_n_1m bias_n_1m nmos
M17 bias_n_1m net_12 source_nmos source_nmos nmos
M18 bias_n_2b bias_n_2b source_nmos source_nmos nmos
M19 bias_n_2t bias_n_2t bias_n_2b bias_n_2b nmos
M20 bias_p_3 bias_p_3 source_pmos source_pmos pmos
M21 ibias ibias source_pmos source_pmos pmos
M22 bias_n_2t ibias source_pmos source_pmos pmos
M23 bias_p_3 bias_n_2b source_nmos source_nmos nmos
M24 net_13 ibias source_pmos source_pmos pmos
Cap_load_1 out source_nmos
Cap_compensation_1 outfirststage out
.end two_stage_single_output_op_amp708
