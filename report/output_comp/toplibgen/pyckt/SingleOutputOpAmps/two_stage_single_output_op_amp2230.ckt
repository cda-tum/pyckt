.suckt  two_stage_single_output_op_amp2230 ibias in1 in2 out source_nmos source_pmos
M1 net_0 in1 net_1 net_1 nmos
M2 outfirststage in2 net_1 net_1 nmos
M3 net_0 net_0 source_nmos source_nmos nmos
M4 outfirststage net_0 source_nmos source_nmos nmos
M5 net_2 bias_p_4 source_pmos source_pmos pmos
M6 net_0 bias_p_3 net_2 net_2 pmos
M7 net_5 bias_p_4 source_pmos source_pmos pmos
M8 outfirststage bias_p_3 net_5 net_5 pmos
M9 net_6 net_6 source_nmos source_nmos nmos
M10 net_1 net_7 net_6 net_6 nmos
M11 net_8 outfirststage source_pmos source_pmos pmos
M12 out bias_p_3 net_8 net_8 pmos
M13 out ibias source_nmos source_nmos nmos
M14 net_7 net_7 bias_n_1m bias_n_1m nmos
M15 bias_n_1m net_6 source_nmos source_nmos nmos
M16 ibias ibias source_nmos source_nmos nmos
M17 bias_p_3 bias_p_3 source_pmos source_pmos pmos
M18 bias_p_4 bias_p_4 source_pmos source_pmos pmos
M19 bias_p_4 ibias source_nmos source_nmos nmos
M20 bias_p_3 ibias source_nmos source_nmos nmos
M21 net_7 bias_p_4 source_pmos source_pmos pmos
Cap_load_1 out source_nmos
Cap_compensation_1 outfirststage out
.end two_stage_single_output_op_amp2230
