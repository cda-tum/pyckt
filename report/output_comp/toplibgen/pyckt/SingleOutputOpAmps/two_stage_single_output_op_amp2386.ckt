.suckt  two_stage_single_output_op_amp2386 ibias in1 in2 out source_nmos source_pmos
M1 net_0 in1 net_1 net_1 nmos
M2 outfirststage in2 net_1 net_1 nmos
M3 net_2 net_0 source_nmos source_nmos nmos
M4 net_0 bias_n_1 net_2 net_2 nmos
M5 net_4 net_0 source_nmos source_nmos nmos
M6 outfirststage bias_n_1 net_4 net_4 nmos
M7 net_0 bias_p_4 source_pmos source_pmos pmos
M8 outfirststage bias_p_4 source_pmos source_pmos pmos
M9 net_6 ibias source_nmos source_nmos nmos
M10 net_1 bias_n_1 net_6 net_6 nmos
M11 net_9 outfirststage source_pmos source_pmos pmos
M12 out bias_p_3 net_9 net_9 pmos
M13 out ibias source_nmos source_nmos nmos
M14 bias_n_1 bias_n_1 source_nmos source_nmos nmos
M15 ibias ibias source_nmos source_nmos nmos
M16 bias_p_3 bias_p_3 source_pmos source_pmos pmos
M17 bias_p_4 bias_p_4 source_pmos source_pmos pmos
M18 bias_p_4 ibias source_nmos source_nmos nmos
M19 bias_n_1 bias_p_4 source_pmos source_pmos pmos
M20 bias_p_3 ibias source_nmos source_nmos nmos
Cap_load_1 out source_nmos
Cap_compensation_1 outfirststage out
.end two_stage_single_output_op_amp2386
