.suckt  two_stage_single_output_op_amp390 ibias in1 in2 out source_nmos source_pmos
M1 net_0 in1 net_1 net_1 nmos
M2 outfirststage in2 net_1 net_1 nmos
M3 net_0 net_0 source_pmos source_pmos pmos
M4 net_2 net_0 source_pmos source_pmos pmos
M5 outfirststage bias_p_4 net_2 net_2 pmos
M6 net_4 ibias source_nmos source_nmos nmos
M7 net_1 bias_n_1 net_4 net_4 nmos
M8 net_7 net_7 source_pmos source_pmos pmos
M9 out net_8 net_7 net_7 pmos
M10 net_9 outfirststage source_nmos source_nmos nmos
M11 out bias_n_1 net_9 net_9 nmos
M12 bias_n_1 bias_n_1 source_nmos source_nmos nmos
M13 ibias ibias source_nmos source_nmos nmos
M14 net_8 net_8 bias_p_3m bias_p_3m pmos
M15 bias_p_3m net_7 source_pmos source_pmos pmos
M16 bias_p_4 bias_p_4 source_pmos source_pmos pmos
M17 bias_p_5 bias_p_5 source_pmos source_pmos pmos
M18 net_8 ibias source_nmos source_nmos nmos
M19 bias_n_1 bias_p_5 source_pmos source_pmos pmos
M20 bias_p_4 ibias source_nmos source_nmos nmos
M21 bias_p_5 ibias source_nmos source_nmos nmos
Cap_load_1 out source_nmos
Cap_compensation_1 outfirststage out
.end two_stage_single_output_op_amp390
