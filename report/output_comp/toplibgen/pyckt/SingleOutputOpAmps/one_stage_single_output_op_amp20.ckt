.suckt  one_stage_single_output_op_amp20 ibias in1 in2 out source_nmos source_pmos
M1 net_0 in1 net_1 net_1 pmos
M2 out in2 net_1 net_1 pmos
M3 net_0 net_0 source_nmos source_nmos nmos
M4 net_2 net_0 source_nmos source_nmos nmos
M5 out bias_n_1 net_2 net_2 nmos
M6 net_4 net_4 source_pmos source_pmos pmos
M7 net_1 ibias net_4 net_4 pmos
M8 bias_n_1 bias_n_1 source_nmos source_nmos nmos
M9 ibias ibias bias_p_2m bias_p_2m pmos
M10 bias_p_2m net_4 source_pmos source_pmos pmos
M11 bias_n_1 net_4 source_pmos source_pmos pmos
Cap_load_1 out source_nmos
.end one_stage_single_output_op_amp20
