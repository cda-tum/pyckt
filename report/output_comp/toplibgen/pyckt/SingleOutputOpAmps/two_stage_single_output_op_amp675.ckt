.suckt  two_stage_single_output_op_amp675 ibias in1 in2 out source_nmos source_pmos
M1 net_0 in1 net_1 net_1 pmos
M2 net_2 in2 net_1 net_1 pmos
M3 net_0 bias_n_1b source_nmos source_nmos nmos
M4 net_4 bias_n_1t net_0 net_0 nmos
M5 net_2 bias_n_1b source_nmos source_nmos nmos
M6 outfirststage bias_n_1t net_2 net_2 nmos
M7 net_4 net_4 source_pmos source_pmos pmos
M8 outfirststage net_4 source_pmos source_pmos pmos
M9 net_6 bias_p_2b source_pmos source_pmos pmos
M10 net_1 ibias net_6 net_6 pmos
M11 net_9 bias_p_2b source_pmos source_pmos pmos
M12 out ibias net_9 net_9 pmos
M13 out outfirststage source_nmos source_nmos nmos
M14 bias_n_1b bias_n_1b source_nmos source_nmos nmos
M15 bias_n_1t bias_n_1t bias_n_1b bias_n_1b nmos
M16 bias_p_2b bias_p_2b source_pmos source_pmos pmos
M17 ibias ibias bias_p_2b bias_p_2b pmos
M18 bias_n_1t bias_p_2b source_pmos source_pmos pmos
Cap_load_1 out source_nmos
Cap_compensation_1 outfirststage out
.end two_stage_single_output_op_amp675
