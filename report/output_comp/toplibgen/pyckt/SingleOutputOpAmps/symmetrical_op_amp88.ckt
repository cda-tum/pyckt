.suckt  symmetrical_op_amp88 ibias in1 in2 out source_nmos source_pmos
M1 out2fs in1 net_0 net_0 pmos
M2 inoutputtc in2 net_0 net_0 pmos
M3 out1fs out1fs source_nmos source_nmos nmos
M4 out2fs out2fs out1fs out1fs nmos
M5 insourcetc insourcetc source_nmos source_nmos nmos
M6 inoutputtc inoutputtc insourcetc insourcetc nmos
M7 net_0 ibias source_pmos source_pmos pmos
M8 net_2 insourcestagebias source_pmos source_pmos pmos
M9 out bias_p_1 net_2 net_2 pmos
M10 net_3 out1fs source_nmos source_nmos nmos
M11 out out2fs net_3 net_3 nmos
M12 net_4 insourcetc source_nmos source_nmos nmos
M13 insourcestagebias inoutputtc net_4 net_4 nmos
M14 net_5 insourcestagebias source_pmos source_pmos pmos
M15 insourcestagebias bias_p_1 net_5 net_5 pmos
M16 bias_p_1 bias_p_1 source_pmos source_pmos pmos
M17 ibias ibias source_pmos source_pmos pmos
M18 bias_n_3 bias_n_3 source_nmos source_nmos nmos
M19 bias_p_1 bias_n_3 source_nmos source_nmos nmos
M20 bias_n_3 ibias source_pmos source_pmos pmos
Cap_load_1 out source_nmos
.end symmetrical_op_amp88
