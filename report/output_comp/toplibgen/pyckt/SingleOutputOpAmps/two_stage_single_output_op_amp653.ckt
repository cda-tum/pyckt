.suckt  two_stage_single_output_op_amp653 ibias in1 in2 out source_nmos source_pmos
M1 net_0 in1 net_1 net_1 nmos
M2 net_2 in2 net_1 net_1 nmos
M3 net_0 bias_p_3b source_pmos source_pmos pmos
M4 net_4 bias_p_3t net_0 net_0 pmos
M5 net_2 bias_p_3b source_pmos source_pmos pmos
M6 outfirststage bias_p_3t net_2 net_2 pmos
M7 net_6 net_7 source_nmos source_nmos nmos
M8 net_4 net_4 net_6 net_6 nmos
M9 net_7 net_7 source_nmos source_nmos nmos
M10 outfirststage net_4 net_7 net_7 nmos
M11 net_1 ibias source_nmos source_nmos nmos
M12 net_9 net_9 source_pmos source_pmos pmos
M13 out net_10 net_9 net_9 pmos
M14 out outfirststage source_nmos source_nmos nmos
M15 ibias ibias source_nmos source_nmos nmos
M16 net_10 net_10 bias_p_2m bias_p_2m pmos
M17 bias_p_2m net_9 source_pmos source_pmos pmos
M18 bias_p_3b bias_p_3b source_pmos source_pmos pmos
M19 bias_p_3t bias_p_3t bias_p_3b bias_p_3b pmos
M20 bias_p_3t ibias source_nmos source_nmos nmos
M21 net_10 ibias source_nmos source_nmos nmos
Cap_load_1 out source_nmos
Cap_compensation_1 outfirststage out
.end two_stage_single_output_op_amp653
