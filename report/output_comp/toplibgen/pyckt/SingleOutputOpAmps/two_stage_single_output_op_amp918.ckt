.suckt  two_stage_single_output_op_amp918 ibias in1 in2 out source_nmos source_pmos
M1 net_0 in1 net_1 net_1 nmos
M2 net_2 in2 net_1 net_1 nmos
M3 net_0 bias_p_4b source_pmos source_pmos pmos
M4 net_4 bias_p_4t net_0 net_0 pmos
M5 net_2 bias_p_4b source_pmos source_pmos pmos
M6 outfirststage bias_p_4t net_2 net_2 pmos
M7 net_6 net_6 source_nmos source_nmos nmos
M8 net_4 net_4 net_6 net_6 nmos
M9 net_7 net_6 source_nmos source_nmos nmos
M10 outfirststage net_4 net_7 net_7 nmos
M11 net_8 ibias source_nmos source_nmos nmos
M12 net_1 bias_n_1 net_8 net_8 nmos
M13 net_11 net_11 source_pmos source_pmos pmos
M14 out net_12 net_11 net_11 pmos
M15 net_13 outfirststage source_nmos source_nmos nmos
M16 out bias_n_1 net_13 net_13 nmos
M17 bias_n_1 bias_n_1 source_nmos source_nmos nmos
M18 ibias ibias source_nmos source_nmos nmos
M19 net_12 net_12 bias_p_3m bias_p_3m pmos
M20 bias_p_3m net_11 source_pmos source_pmos pmos
M21 bias_p_4b bias_p_4b source_pmos source_pmos pmos
M22 bias_p_4t bias_p_4t bias_p_4b bias_p_4b pmos
M23 bias_p_4t ibias source_nmos source_nmos nmos
M24 bias_n_1 bias_p_4b source_pmos source_pmos pmos
M25 net_12 ibias source_nmos source_nmos nmos
Cap_load_1 out source_nmos
Cap_compensation_1 outfirststage out
.end two_stage_single_output_op_amp918
