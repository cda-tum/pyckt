.suckt  two_stage_single_output_op_amp1711 ibias in1 in2 out source_nmos source_pmos
M1 net_0 in1 net_1 net_1 nmos
M2 outfirststage in2 net_1 net_1 nmos
M3 net_0 net_2 source_nmos source_nmos nmos
M4 net_2 net_2 source_nmos source_nmos nmos
M5 outfirststage net_0 net_2 net_2 nmos
M6 net_0 bias_p_2 source_pmos source_pmos pmos
M7 outfirststage bias_p_2 source_pmos source_pmos pmos
M8 net_1 ibias source_nmos source_nmos nmos
M9 out outfirststage source_pmos source_pmos pmos
M10 out ibias source_nmos source_nmos nmos
M11 ibias ibias source_nmos source_nmos nmos
M12 bias_p_2 bias_p_2 source_pmos source_pmos pmos
M13 bias_p_2 ibias source_nmos source_nmos nmos
Cap_load_1 out source_nmos
Cap_compensation_1 outfirststage out
.end two_stage_single_output_op_amp1711
