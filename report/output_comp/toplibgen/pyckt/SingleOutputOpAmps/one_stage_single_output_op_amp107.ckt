.suckt  one_stage_single_output_op_amp107 ibias in1 in2 out source_nmos source_pmos
M1 net_0 in1 net_1 net_1 pmos
M2 net_2 in2 net_1 net_1 pmos
M3 net_3 net_4 net_0 net_0 pmos
M4 out net_4 net_2 net_2 pmos
M5 net_5 net_3 source_nmos source_nmos nmos
M6 net_3 bias_n_1 net_5 net_5 nmos
M7 net_7 net_3 source_nmos source_nmos nmos
M8 out bias_n_1 net_7 net_7 nmos
M9 net_8 bias_p_2b source_pmos source_pmos pmos
M10 net_1 ibias net_8 net_8 pmos
M11 bias_n_1 bias_n_1 source_nmos source_nmos nmos
M12 net_4 net_4 net_1 net_1 pmos
M13 bias_p_2b bias_p_2b source_pmos source_pmos pmos
M14 ibias ibias bias_p_2b bias_p_2b pmos
M15 bias_n_3 bias_n_3 source_nmos source_nmos nmos
M16 bias_n_1 bias_p_2b source_pmos source_pmos pmos
M17 net_4 bias_n_3 source_nmos source_nmos nmos
M18 bias_n_3 bias_p_2b source_pmos source_pmos pmos
Cap_load_1 out source_nmos
.end one_stage_single_output_op_amp107
