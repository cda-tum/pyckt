.suckt  two_stage_single_output_op_amp1383 ibias in1 in2 out source_nmos source_pmos
M1 net_0 in1 net_1 net_1 nmos
M2 net_2 in2 net_1 net_1 nmos
M3 net_3 net_4 net_0 net_0 nmos
M4 outfirststage net_4 net_2 net_2 nmos
M5 net_3 net_5 source_pmos source_pmos pmos
M6 net_5 net_5 source_pmos source_pmos pmos
M7 outfirststage net_3 net_5 net_5 pmos
M8 net_6 net_6 source_nmos source_nmos nmos
M9 net_1 net_7 net_6 net_6 nmos
M10 net_8 bias_p_2b source_pmos source_pmos pmos
M11 out ibias net_8 net_8 pmos
M12 out outfirststage source_nmos source_nmos nmos
M13 net_4 net_4 net_1 net_1 nmos
M14 net_7 net_7 bias_n_1m bias_n_1m nmos
M15 bias_n_1m net_6 source_nmos source_nmos nmos
M16 bias_p_2b bias_p_2b source_pmos source_pmos pmos
M17 ibias ibias bias_p_2b bias_p_2b pmos
M18 net_7 bias_p_2b source_pmos source_pmos pmos
M19 net_4 bias_p_2b source_pmos source_pmos pmos
Cap_load_1 out source_nmos
Cap_compensation_1 outfirststage out
.end two_stage_single_output_op_amp1383
