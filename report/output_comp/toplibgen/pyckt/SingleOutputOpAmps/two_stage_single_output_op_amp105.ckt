.suckt  two_stage_single_output_op_amp105 ibias in1 in2 out source_nmos source_pmos
M1 net_0 in1 net_1 net_1 nmos
M2 outfirststage in2 net_1 net_1 nmos
M3 net_0 net_2 source_pmos source_pmos pmos
M4 net_2 net_2 source_pmos source_pmos pmos
M5 outfirststage net_0 net_2 net_2 pmos
M6 net_1 ibias source_nmos source_nmos nmos
M7 out outfirststage source_pmos source_pmos pmos
M8 net_4 net_4 source_nmos source_nmos nmos
M9 out net_5 net_4 net_4 nmos
M10 net_5 net_5 bias_n_1m bias_n_1m nmos
M11 bias_n_1m net_4 source_nmos source_nmos nmos
M12 ibias ibias source_nmos source_nmos nmos
M13 bias_p_3 bias_p_3 source_pmos source_pmos pmos
M14 net_5 bias_p_3 source_pmos source_pmos pmos
M15 bias_p_3 ibias source_nmos source_nmos nmos
Cap_load_1 out source_nmos
Cap_compensation_1 outfirststage out
.end two_stage_single_output_op_amp105
