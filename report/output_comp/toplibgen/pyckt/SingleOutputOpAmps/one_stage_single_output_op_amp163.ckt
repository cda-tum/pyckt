.suckt  one_stage_single_output_op_amp163 ibias in1 in2 out source_nmos source_pmos
M1 net_0 in1 net_1 net_1 pmos
M2 out in2 net_1 net_1 pmos
M3 net_0 net_0 source_pmos source_pmos pmos
M4 net_2 net_0 source_pmos source_pmos pmos
M5 out bias_p_2 net_2 net_2 pmos
M6 net_0 ibias source_nmos source_nmos nmos
M7 out ibias source_nmos source_nmos nmos
M8 net_5 bias_p_3 source_pmos source_pmos pmos
M9 net_1 bias_p_2 net_5 net_5 pmos
M10 ibias ibias source_nmos source_nmos nmos
M11 bias_p_2 bias_p_2 source_pmos source_pmos pmos
M12 bias_p_3 bias_p_3 source_pmos source_pmos pmos
M13 bias_p_3 ibias source_nmos source_nmos nmos
M14 bias_p_2 ibias source_nmos source_nmos nmos
Cap_load_1 out source_nmos
.end one_stage_single_output_op_amp163
