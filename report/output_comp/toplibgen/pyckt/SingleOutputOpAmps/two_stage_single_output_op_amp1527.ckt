.suckt  two_stage_single_output_op_amp1527 ibias in1 in2 out source_nmos source_pmos
M1 net_0 in1 net_1 net_1 pmos
M2 outfirststage in2 net_1 net_1 pmos
M3 net_0 net_0 source_pmos source_pmos pmos
M4 outfirststage net_0 source_pmos source_pmos pmos
M5 net_2 bias_n_1b source_nmos source_nmos nmos
M6 net_0 ibias net_2 net_2 nmos
M7 net_5 bias_n_1b source_nmos source_nmos nmos
M8 outfirststage ibias net_5 net_5 nmos
M9 net_1 bias_p_3 source_pmos source_pmos pmos
M10 net_7 bias_p_3 source_pmos source_pmos pmos
M11 out bias_p_2 net_7 net_7 pmos
M12 out outfirststage source_nmos source_nmos nmos
M13 bias_n_1b bias_n_1b source_nmos source_nmos nmos
M14 ibias ibias bias_n_1b bias_n_1b nmos
M15 bias_p_2 bias_p_2 source_pmos source_pmos pmos
M16 bias_p_3 bias_p_3 source_pmos source_pmos pmos
M17 bias_p_3 bias_n_1b source_nmos source_nmos nmos
M18 bias_p_2 bias_n_1b source_nmos source_nmos nmos
Cap_load_1 out source_nmos
Cap_compensation_1 outfirststage out
.end two_stage_single_output_op_amp1527
