.suckt  two_stage_single_output_op_amp337 ibias in1 in2 out source_nmos source_pmos
M1 net_0 in1 net_1 net_1 nmos
M2 outfirststage in2 net_1 net_1 nmos
M3 net_0 net_0 source_pmos source_pmos pmos
M4 outfirststage net_0 source_pmos source_pmos pmos
M5 net_2 bias_n_1b source_nmos source_nmos nmos
M6 net_1 ibias net_2 net_2 nmos
M7 out bias_p_2 source_pmos source_pmos pmos
M8 out outfirststage source_nmos source_nmos nmos
M9 bias_n_1b bias_n_1b source_nmos source_nmos nmos
M10 ibias ibias bias_n_1b bias_n_1b nmos
M11 bias_p_2 bias_p_2 source_pmos source_pmos pmos
M12 bias_p_2 bias_n_1b source_nmos source_nmos nmos
Cap_load_1 out source_nmos
Cap_compensation_1 outfirststage out
.end two_stage_single_output_op_amp337
