.suckt  two_stage_single_output_op_amp196 ibias in1 in2 out source_nmos source_pmos
M1 net_0 in1 net_1 net_1 pmos
M2 outfirststage in2 net_1 net_1 pmos
M3 net_0 net_2 source_nmos source_nmos nmos
M4 net_2 net_2 source_nmos source_nmos nmos
M5 outfirststage net_0 net_2 net_2 nmos
M6 net_3 bias_p_2b source_pmos source_pmos pmos
M7 net_1 ibias net_3 net_3 pmos
M8 net_6 bias_p_2b source_pmos source_pmos pmos
M9 out ibias net_6 net_6 pmos
M10 net_9 outfirststage source_nmos source_nmos nmos
M11 out bias_n_1 net_9 net_9 nmos
M12 bias_n_1 bias_n_1 source_nmos source_nmos nmos
M13 bias_p_2b bias_p_2b source_pmos source_pmos pmos
M14 ibias ibias bias_p_2b bias_p_2b pmos
M15 bias_n_1 bias_p_2b source_pmos source_pmos pmos
Cap_load_1 out source_nmos
Cap_compensation_1 outfirststage out
.end two_stage_single_output_op_amp196
