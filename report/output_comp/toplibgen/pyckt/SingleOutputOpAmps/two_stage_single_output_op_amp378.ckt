.suckt  two_stage_single_output_op_amp378 ibias in1 in2 out source_nmos source_pmos
M1 net_0 in1 net_1 net_1 nmos
M2 outfirststage in2 net_1 net_1 nmos
M3 net_0 net_2 source_pmos source_pmos pmos
M4 net_2 net_2 source_pmos source_pmos pmos
M5 outfirststage net_0 net_2 net_2 pmos
M6 net_3 net_3 source_nmos source_nmos nmos
M7 net_1 net_4 net_3 net_3 nmos
M8 net_5 net_5 source_pmos source_pmos pmos
M9 out ibias net_5 net_5 pmos
M10 net_7 outfirststage source_nmos source_nmos nmos
M11 out bias_n_2 net_7 net_7 nmos
M12 net_4 net_4 bias_n_1m bias_n_1m nmos
M13 bias_n_1m net_3 source_nmos source_nmos nmos
M14 bias_n_2 bias_n_2 source_nmos source_nmos nmos
M15 ibias ibias bias_p_3m bias_p_3m pmos
M16 bias_p_3m net_5 source_pmos source_pmos pmos
M17 net_4 net_5 source_pmos source_pmos pmos
M18 bias_n_2 net_5 source_pmos source_pmos pmos
Cap_load_1 out source_nmos
Cap_compensation_1 outfirststage out
.end two_stage_single_output_op_amp378
