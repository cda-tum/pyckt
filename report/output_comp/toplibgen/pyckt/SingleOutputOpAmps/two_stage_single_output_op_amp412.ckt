.suckt  two_stage_single_output_op_amp412 ibias in1 in2 out source_nmos source_pmos
M1 net_0 in1 net_1 net_1 nmos
M2 outfirststage in2 net_1 net_1 nmos
M3 net_2 net_2 source_pmos source_pmos pmos
M4 net_0 net_0 net_2 net_2 pmos
M5 net_3 net_2 source_pmos source_pmos pmos
M6 outfirststage net_0 net_3 net_3 pmos
M7 net_4 bias_n_2 source_nmos source_nmos nmos
M8 net_1 bias_n_1 net_4 net_4 nmos
M9 net_7 bias_p_3b source_pmos source_pmos pmos
M10 out ibias net_7 net_7 pmos
M11 net_10 outfirststage source_nmos source_nmos nmos
M12 out bias_n_1 net_10 net_10 nmos
M13 bias_n_1 bias_n_1 source_nmos source_nmos nmos
M14 bias_n_2 bias_n_2 source_nmos source_nmos nmos
M15 bias_p_3b bias_p_3b source_pmos source_pmos pmos
M16 ibias ibias bias_p_3b bias_p_3b pmos
M17 bias_n_2 bias_p_3b source_pmos source_pmos pmos
M18 bias_n_1 bias_p_3b source_pmos source_pmos pmos
Cap_load_1 out source_nmos
Cap_compensation_1 outfirststage out
.end two_stage_single_output_op_amp412
