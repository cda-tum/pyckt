.suckt  two_stage_single_output_op_amp14 ibias in1 in2 out source_nmos source_pmos
M1 net_0 in1 net_1 net_1 pmos
M2 outfirststage in2 net_1 net_1 pmos
M3 net_0 net_2 source_nmos source_nmos nmos
M4 net_2 net_2 source_nmos source_nmos nmos
M5 outfirststage net_0 net_2 net_2 nmos
M6 net_1 ibias source_pmos source_pmos pmos
M7 out ibias source_pmos source_pmos pmos
M8 net_5 outfirststage source_nmos source_nmos nmos
M9 out bias_n_1 net_5 net_5 nmos
M10 bias_n_1 bias_n_1 source_nmos source_nmos nmos
M11 ibias ibias source_pmos source_pmos pmos
M12 bias_n_1 ibias source_pmos source_pmos pmos
Cap_load_1 out source_nmos
Cap_compensation_1 outfirststage out
.end two_stage_single_output_op_amp14
