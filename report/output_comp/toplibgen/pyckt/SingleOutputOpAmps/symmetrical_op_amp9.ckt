.suckt  symmetrical_op_amp9 ibias in1 in2 out source_nmos source_pmos
M1 out1fs in1 net_0 net_0 pmos
M2 out2fs in2 net_0 net_0 pmos
M3 out1fs out1fs source_nmos source_nmos nmos
M4 out2fs out2fs source_nmos source_nmos nmos
M5 net_0 ibias source_pmos source_pmos pmos
M6 net_2 insourcestagebias source_pmos source_pmos pmos
M7 out bias_p_2 net_2 net_2 pmos
M8 net_3 out1fs source_nmos source_nmos nmos
M9 out bias_n_1 net_3 net_3 nmos
M10 net_4 out2fs source_nmos source_nmos nmos
M11 insourcestagebias bias_n_1 net_4 net_4 nmos
M12 net_5 insourcestagebias source_pmos source_pmos pmos
M13 insourcestagebias bias_p_2 net_5 net_5 pmos
M14 bias_n_1 bias_n_1 source_nmos source_nmos nmos
M15 bias_p_2 bias_p_2 source_pmos source_pmos pmos
M16 ibias ibias source_pmos source_pmos pmos
M17 bias_n_4 bias_n_4 source_nmos source_nmos nmos
M18 bias_n_1 ibias source_pmos source_pmos pmos
M19 bias_p_2 bias_n_4 source_nmos source_nmos nmos
M20 bias_n_4 ibias source_pmos source_pmos pmos
Cap_load_1 out source_nmos
.end symmetrical_op_amp9
