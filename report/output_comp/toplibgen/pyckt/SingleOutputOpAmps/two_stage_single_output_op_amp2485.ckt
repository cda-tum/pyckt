.suckt  two_stage_single_output_op_amp2485 ibias in1 in2 out source_nmos source_pmos
M1 net_0 in1 net_1 net_1 nmos
M2 outfirststage in2 net_1 net_1 nmos
M3 net_2 net_0 source_nmos source_nmos nmos
M4 net_0 net_0 net_2 net_2 nmos
M5 net_3 net_0 source_nmos source_nmos nmos
M6 outfirststage net_0 net_3 net_3 nmos
M7 net_0 bias_p_2 source_pmos source_pmos pmos
M8 outfirststage bias_p_2 source_pmos source_pmos pmos
M9 net_5 net_5 source_nmos source_nmos nmos
M10 net_1 ibias net_5 net_5 nmos
M11 out bias_p_2 source_pmos source_pmos pmos
M12 out outfirststage source_nmos source_nmos nmos
M13 ibias ibias bias_n_1m bias_n_1m nmos
M14 bias_n_1m net_5 source_nmos source_nmos nmos
M15 bias_p_2 bias_p_2 source_pmos source_pmos pmos
M16 bias_p_2 net_5 source_nmos source_nmos nmos
Cap_load_1 out source_nmos
Cap_compensation_1 outfirststage out
.end two_stage_single_output_op_amp2485
