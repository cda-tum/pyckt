.suckt  two_stage_single_output_op_amp960 ibias in1 in2 out source_nmos source_pmos
M1 net_0 in1 net_1 net_1 nmos
M2 net_2 in2 net_1 net_1 nmos
M3 net_0 ibias source_pmos source_pmos pmos
M4 net_4 bias_p_4 net_0 net_0 pmos
M5 net_2 ibias source_pmos source_pmos pmos
M6 outfirststage bias_p_4 net_2 net_2 pmos
M7 net_6 net_4 source_nmos source_nmos nmos
M8 net_4 bias_n_3 net_6 net_6 nmos
M9 net_8 net_4 source_nmos source_nmos nmos
M10 outfirststage bias_n_3 net_8 net_8 nmos
M11 net_9 net_9 source_nmos source_nmos nmos
M12 net_1 net_10 net_9 net_9 nmos
M13 net_11 outfirststage source_pmos source_pmos pmos
M14 out bias_p_4 net_11 net_11 pmos
M15 net_13 net_13 source_nmos source_nmos nmos
M16 out net_14 net_13 net_13 nmos
M17 net_10 net_10 bias_n_1m bias_n_1m nmos
M18 bias_n_1m net_9 source_nmos source_nmos nmos
M19 net_14 net_14 bias_n_2m bias_n_2m nmos
M20 bias_n_2m net_13 source_nmos source_nmos nmos
M21 bias_n_3 bias_n_3 source_nmos source_nmos nmos
M22 bias_p_4 bias_p_4 source_pmos source_pmos pmos
M23 ibias ibias source_pmos source_pmos pmos
M24 bias_n_6 bias_n_6 source_nmos source_nmos nmos
M25 net_14 ibias source_pmos source_pmos pmos
M26 bias_n_3 ibias source_pmos source_pmos pmos
M27 bias_p_4 bias_n_6 source_nmos source_nmos nmos
M28 net_10 ibias source_pmos source_pmos pmos
M29 bias_n_6 ibias source_pmos source_pmos pmos
Cap_load_1 out source_nmos
Cap_compensation_1 outfirststage out
.end two_stage_single_output_op_amp960
