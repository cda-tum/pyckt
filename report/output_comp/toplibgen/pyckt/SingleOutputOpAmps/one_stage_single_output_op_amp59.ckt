.suckt  one_stage_single_output_op_amp59 ibias in1 in2 out source_nmos source_pmos
M1 net_0 in1 net_1 net_1 pmos
M2 net_2 in2 net_1 net_1 pmos
M3 net_0 bias_n_1b source_nmos source_nmos nmos
M4 net_4 bias_n_1t net_0 net_0 nmos
M5 net_2 bias_n_1b source_nmos source_nmos nmos
M6 out bias_n_1t net_2 net_2 nmos
M7 net_4 net_6 source_pmos source_pmos pmos
M8 net_6 net_6 source_pmos source_pmos pmos
M9 out net_4 net_6 net_6 pmos
M10 net_7 bias_p_2b source_pmos source_pmos pmos
M11 net_1 ibias net_7 net_7 pmos
M12 bias_n_1b bias_n_1b source_nmos source_nmos nmos
M13 bias_n_1t bias_n_1t bias_n_1b bias_n_1b nmos
M14 bias_p_2b bias_p_2b source_pmos source_pmos pmos
M15 ibias ibias bias_p_2b bias_p_2b pmos
M16 bias_n_1t bias_p_2b source_pmos source_pmos pmos
Cap_load_1 out source_nmos
.end one_stage_single_output_op_amp59
