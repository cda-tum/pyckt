.suckt  one_stage_single_output_op_amp137 ibias in1 in2 out source_nmos source_pmos
M1 net_0 in1 net_1 net_1 pmos
M2 out in2 net_1 net_1 pmos
M3 net_2 net_3 source_pmos source_pmos pmos
M4 net_0 net_0 net_2 net_2 pmos
M5 net_3 net_3 source_pmos source_pmos pmos
M6 out net_0 net_3 net_3 pmos
M7 net_0 bias_n_1 source_nmos source_nmos nmos
M8 out bias_n_1 source_nmos source_nmos nmos
M9 net_1 ibias source_pmos source_pmos pmos
M10 bias_n_1 bias_n_1 source_nmos source_nmos nmos
M11 ibias ibias source_pmos source_pmos pmos
M12 bias_n_1 ibias source_pmos source_pmos pmos
Cap_load_1 out source_nmos
.end one_stage_single_output_op_amp137
