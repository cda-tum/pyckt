.suckt  two_stage_single_output_op_amp191 ibias in1 in2 out source_nmos source_pmos
M1 net_0 in1 net_1 net_1 pmos
M2 outfirststage in2 net_1 net_1 pmos
M3 net_0 net_0 source_nmos source_nmos nmos
M4 outfirststage net_0 source_nmos source_nmos nmos
M5 net_2 net_2 source_pmos source_pmos pmos
M6 net_1 net_3 net_2 net_2 pmos
M7 net_4 outfirststage source_pmos source_pmos pmos
M8 out bias_p_3 net_4 net_4 pmos
M9 net_6 bias_n_1b source_nmos source_nmos nmos
M10 out ibias net_6 net_6 nmos
M11 bias_n_1b bias_n_1b source_nmos source_nmos nmos
M12 ibias ibias bias_n_1b bias_n_1b nmos
M13 net_3 net_3 bias_p_2m bias_p_2m pmos
M14 bias_p_2m net_2 source_pmos source_pmos pmos
M15 bias_p_3 bias_p_3 source_pmos source_pmos pmos
M16 net_3 bias_n_1b source_nmos source_nmos nmos
M17 bias_p_3 bias_n_1b source_nmos source_nmos nmos
Cap_load_1 out source_nmos
Cap_compensation_1 outfirststage out
.end two_stage_single_output_op_amp191
