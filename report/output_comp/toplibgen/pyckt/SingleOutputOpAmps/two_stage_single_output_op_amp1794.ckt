.suckt  two_stage_single_output_op_amp1794 ibias in1 in2 out source_nmos source_pmos
M1 net_0 in1 net_1 net_1 nmos
M2 outfirststage in2 net_1 net_1 nmos
M3 net_2 net_0 source_nmos source_nmos nmos
M4 net_0 bias_n_1 net_2 net_2 nmos
M5 net_4 net_0 source_nmos source_nmos nmos
M6 outfirststage bias_n_1 net_4 net_4 nmos
M7 net_5 bias_p_4b source_pmos source_pmos pmos
M8 net_0 bias_p_4t net_5 net_5 pmos
M9 net_8 bias_p_4b source_pmos source_pmos pmos
M10 outfirststage bias_p_4t net_8 net_8 pmos
M11 net_1 ibias source_nmos source_nmos nmos
M12 net_10 net_10 source_pmos source_pmos pmos
M13 out net_11 net_10 net_10 pmos
M14 net_12 outfirststage source_nmos source_nmos nmos
M15 out bias_n_1 net_12 net_12 nmos
M16 bias_n_1 bias_n_1 source_nmos source_nmos nmos
M17 ibias ibias source_nmos source_nmos nmos
M18 net_11 net_11 bias_p_3m bias_p_3m pmos
M19 bias_p_3m net_10 source_pmos source_pmos pmos
M20 bias_p_4b bias_p_4b source_pmos source_pmos pmos
M21 bias_p_4t bias_p_4t bias_p_4b bias_p_4b pmos
M22 bias_p_4t ibias source_nmos source_nmos nmos
M23 bias_n_1 bias_p_4b source_pmos source_pmos pmos
M24 net_11 ibias source_nmos source_nmos nmos
Cap_load_1 out source_nmos
Cap_compensation_1 outfirststage out
.end two_stage_single_output_op_amp1794
