.suckt  symmetrical_op_amp52 ibias in1 in2 out source_nmos source_pmos
M1 out1fs in1 net_0 net_0 pmos
M2 out2fs in2 net_0 net_0 pmos
M3 out1fs out1fs source_nmos source_nmos nmos
M4 out2fs out2fs source_nmos source_nmos nmos
M5 net_1 net_1 source_pmos source_pmos pmos
M6 net_0 ibias net_1 net_1 pmos
M7 net_3 inoutputstagebias source_pmos source_pmos pmos
M8 out inoutputstagebias net_3 net_3 pmos
M9 net_4 out1fs source_nmos source_nmos nmos
M10 out bias_n_1 net_4 net_4 nmos
M11 net_5 out2fs source_nmos source_nmos nmos
M12 inoutputstagebias bias_n_1 net_5 net_5 nmos
M13 net_6 inoutputstagebias source_pmos source_pmos pmos
M14 inoutputstagebias inoutputstagebias net_6 net_6 pmos
M15 bias_n_1 bias_n_1 source_nmos source_nmos nmos
M16 ibias ibias bias_p_2m bias_p_2m pmos
M17 bias_p_2m net_1 source_pmos source_pmos pmos
M18 bias_n_1 net_1 source_pmos source_pmos pmos
Cap_load_1 out source_nmos
.end symmetrical_op_amp52
