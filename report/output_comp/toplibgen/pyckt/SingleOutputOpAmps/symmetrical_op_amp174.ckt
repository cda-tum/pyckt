.suckt  symmetrical_op_amp174 ibias in1 in2 out source_nmos source_pmos
M1 out2fs in1 net_0 net_0 nmos
M2 inoutputtc in2 net_0 net_0 nmos
M3 out1fs out1fs source_pmos source_pmos pmos
M4 out2fs out2fs out1fs out1fs pmos
M5 insourcetc insourcetc source_pmos source_pmos pmos
M6 inoutputtc inoutputtc insourcetc insourcetc pmos
M7 net_1 bias_n_1b source_nmos source_nmos nmos
M8 net_0 ibias net_1 net_1 nmos
M9 net_4 out1fs source_pmos source_pmos pmos
M10 out out2fs net_4 net_4 pmos
M11 instagebias instagebias source_nmos source_nmos nmos
M12 out innercomp instagebias instagebias nmos
M13 net_5 insourcetc source_pmos source_pmos pmos
M14 innercomp inoutputtc net_5 net_5 pmos
M15 innercomp instagebias source_nmos source_nmos nmos
M16 bias_n_1b bias_n_1b source_nmos source_nmos nmos
M17 ibias ibias bias_n_1b bias_n_1b nmos
Cap_load_1 out source_nmos
.end symmetrical_op_amp174
