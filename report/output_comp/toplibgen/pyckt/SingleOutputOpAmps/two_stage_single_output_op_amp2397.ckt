.suckt  two_stage_single_output_op_amp2397 ibias in1 in2 out source_nmos source_pmos
M1 net_0 in1 net_1 net_1 nmos
M2 outfirststage in2 net_1 net_1 nmos
M3 net_2 net_0 source_nmos source_nmos nmos
M4 net_0 bias_n_3 net_2 net_2 nmos
M5 net_4 net_0 source_nmos source_nmos nmos
M6 outfirststage bias_n_3 net_4 net_4 nmos
M7 net_0 ibias source_pmos source_pmos pmos
M8 outfirststage ibias source_pmos source_pmos pmos
M9 net_6 net_6 source_nmos source_nmos nmos
M10 net_1 net_7 net_6 net_6 nmos
M11 out outfirststage source_pmos source_pmos pmos
M12 net_8 net_8 source_nmos source_nmos nmos
M13 out net_9 net_8 net_8 nmos
M14 net_7 net_7 bias_n_1m bias_n_1m nmos
M15 bias_n_1m net_6 source_nmos source_nmos nmos
M16 net_9 net_9 bias_n_2m bias_n_2m nmos
M17 bias_n_2m net_8 source_nmos source_nmos nmos
M18 bias_n_3 bias_n_3 source_nmos source_nmos nmos
M19 ibias ibias source_pmos source_pmos pmos
M20 net_9 ibias source_pmos source_pmos pmos
M21 bias_n_3 ibias source_pmos source_pmos pmos
M22 net_7 ibias source_pmos source_pmos pmos
Cap_load_1 out source_nmos
Cap_compensation_1 outfirststage out
.end two_stage_single_output_op_amp2397
