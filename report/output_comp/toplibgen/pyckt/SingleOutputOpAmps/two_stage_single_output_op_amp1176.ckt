.suckt  two_stage_single_output_op_amp1176 ibias in1 in2 out source_nmos source_pmos
M1 net_0 in1 net_1 net_1 nmos
M2 net_2 in2 net_1 net_1 nmos
M3 net_3 net_4 net_0 net_0 nmos
M4 outfirststage net_4 net_2 net_2 nmos
M5 net_5 net_3 source_pmos source_pmos pmos
M6 net_3 net_3 net_5 net_5 pmos
M7 net_6 net_3 source_pmos source_pmos pmos
M8 outfirststage net_3 net_6 net_6 pmos
M9 net_1 ibias source_nmos source_nmos nmos
M10 net_8 outfirststage source_pmos source_pmos pmos
M11 out bias_p_3 net_8 net_8 pmos
M12 net_10 net_10 source_nmos source_nmos nmos
M13 out net_11 net_10 net_10 nmos
M14 net_4 net_4 net_1 net_1 nmos
M15 net_11 net_11 bias_n_1m bias_n_1m nmos
M16 bias_n_1m net_10 source_nmos source_nmos nmos
M17 ibias ibias source_nmos source_nmos nmos
M18 bias_p_3 bias_p_3 source_pmos source_pmos pmos
M19 bias_p_4 bias_p_4 source_pmos source_pmos pmos
M20 net_4 bias_p_4 source_pmos source_pmos pmos
M21 bias_p_3 ibias source_nmos source_nmos nmos
M22 net_11 bias_p_4 source_pmos source_pmos pmos
M23 bias_p_4 ibias source_nmos source_nmos nmos
Cap_load_1 out source_nmos
Cap_compensation_1 outfirststage out
.end two_stage_single_output_op_amp1176
