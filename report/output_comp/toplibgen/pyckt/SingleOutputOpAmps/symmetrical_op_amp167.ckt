.suckt  symmetrical_op_amp167 ibias in1 in2 out source_nmos source_pmos
M1 out2fs in1 net_0 net_0 pmos
M2 inoutputtc in2 net_0 net_0 pmos
M3 net_1 out2fs source_nmos source_nmos nmos
M4 out2fs out2fs net_1 net_1 nmos
M5 net_2 inoutputtc source_nmos source_nmos nmos
M6 inoutputtc inoutputtc net_2 net_2 nmos
M7 net_3 net_3 source_pmos source_pmos pmos
M8 net_0 ibias net_3 net_3 pmos
M9 instagebias instagebias source_pmos source_pmos pmos
M10 out innercomp instagebias instagebias pmos
M11 net_5 out2fs source_nmos source_nmos nmos
M12 out out2fs net_5 net_5 nmos
M13 net_6 inoutputtc source_nmos source_nmos nmos
M14 innercomp inoutputtc net_6 net_6 nmos
M15 innercomp instagebias source_pmos source_pmos pmos
M16 ibias ibias bias_p_1m bias_p_1m pmos
M17 bias_p_1m net_3 source_pmos source_pmos pmos
Cap_load_1 out source_nmos
.end symmetrical_op_amp167
