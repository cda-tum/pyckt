.suckt  two_stage_single_output_op_amp1448 ibias in1 in2 out source_nmos source_pmos
M1 net_0 in1 net_1 net_1 nmos
M2 net_2 in2 net_1 net_1 nmos
M3 net_3 net_4 net_0 net_0 nmos
M4 outfirststage net_4 net_2 net_2 nmos
M5 net_5 net_3 source_pmos source_pmos pmos
M6 net_3 bias_p_2 net_5 net_5 pmos
M7 net_7 net_3 source_pmos source_pmos pmos
M8 outfirststage bias_p_2 net_7 net_7 pmos
M9 net_8 bias_n_1b source_nmos source_nmos nmos
M10 net_1 ibias net_8 net_8 nmos
M11 out outfirststage source_pmos source_pmos pmos
M12 net_11 bias_n_1b source_nmos source_nmos nmos
M13 out ibias net_11 net_11 nmos
M14 net_4 net_4 net_1 net_1 nmos
M15 bias_n_1b bias_n_1b source_nmos source_nmos nmos
M16 ibias ibias bias_n_1b bias_n_1b nmos
M17 bias_p_2 bias_p_2 source_pmos source_pmos pmos
M18 bias_p_3 bias_p_3 source_pmos source_pmos pmos
M19 net_4 bias_p_3 source_pmos source_pmos pmos
M20 bias_p_2 bias_n_1b source_nmos source_nmos nmos
M21 bias_p_3 bias_n_1b source_nmos source_nmos nmos
Cap_load_1 out source_nmos
Cap_compensation_1 outfirststage out
.end two_stage_single_output_op_amp1448
