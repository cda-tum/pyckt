.suckt  two_stage_single_output_op_amp344 ibias in1 in2 out source_nmos source_pmos
M1 net_0 in1 net_1 net_1 nmos
M2 outfirststage in2 net_1 net_1 nmos
M3 net_0 net_0 source_pmos source_pmos pmos
M4 outfirststage net_0 source_pmos source_pmos pmos
M5 net_2 bias_n_1b source_nmos source_nmos nmos
M6 net_1 ibias net_2 net_2 nmos
M7 out outfirststage source_pmos source_pmos pmos
M8 net_5 bias_n_1b source_nmos source_nmos nmos
M9 out ibias net_5 net_5 nmos
M10 bias_n_1b bias_n_1b source_nmos source_nmos nmos
M11 ibias ibias bias_n_1b bias_n_1b nmos
Cap_load_1 out source_nmos
Cap_compensation_1 outfirststage out
.end two_stage_single_output_op_amp344
