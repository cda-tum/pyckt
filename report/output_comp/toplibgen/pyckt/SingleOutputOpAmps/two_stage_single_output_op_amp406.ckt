.suckt  two_stage_single_output_op_amp406 ibias in1 in2 out source_nmos source_pmos
M1 net_0 in1 net_1 net_1 nmos
M2 outfirststage in2 net_1 net_1 nmos
M3 net_0 net_0 source_pmos source_pmos pmos
M4 net_2 net_0 source_pmos source_pmos pmos
M5 outfirststage bias_p_3 net_2 net_2 pmos
M6 net_4 net_4 source_nmos source_nmos nmos
M7 net_1 net_5 net_4 net_4 nmos
M8 net_6 outfirststage source_pmos source_pmos pmos
M9 out bias_p_3 net_6 net_6 pmos
M10 out ibias source_nmos source_nmos nmos
M11 net_5 net_5 bias_n_1m bias_n_1m nmos
M12 bias_n_1m net_4 source_nmos source_nmos nmos
M13 ibias ibias source_nmos source_nmos nmos
M14 bias_p_3 bias_p_3 source_pmos source_pmos pmos
M15 bias_p_4 bias_p_4 source_pmos source_pmos pmos
M16 bias_p_3 ibias source_nmos source_nmos nmos
M17 net_5 bias_p_4 source_pmos source_pmos pmos
M18 bias_p_4 ibias source_nmos source_nmos nmos
Cap_load_1 out source_nmos
Cap_compensation_1 outfirststage out
.end two_stage_single_output_op_amp406
