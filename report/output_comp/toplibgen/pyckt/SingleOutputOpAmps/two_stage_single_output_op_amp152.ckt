.suckt  two_stage_single_output_op_amp152 ibias in1 in2 out source_nmos source_pmos
M1 net_0 in1 net_1 net_1 nmos
M2 outfirststage in2 net_1 net_1 nmos
M3 net_2 net_3 source_pmos source_pmos pmos
M4 net_0 net_0 net_2 net_2 pmos
M5 net_3 net_3 source_pmos source_pmos pmos
M6 outfirststage net_0 net_3 net_3 pmos
M7 net_1 ibias source_nmos source_nmos nmos
M8 out outfirststage source_pmos source_pmos pmos
M9 net_5 ibias source_nmos source_nmos nmos
M10 out bias_n_1 net_5 net_5 nmos
M11 bias_n_1 bias_n_1 source_nmos source_nmos nmos
M12 ibias ibias source_nmos source_nmos nmos
M13 bias_p_3 bias_p_3 source_pmos source_pmos pmos
M14 bias_n_1 bias_p_3 source_pmos source_pmos pmos
M15 bias_p_3 ibias source_nmos source_nmos nmos
Cap_load_1 out source_nmos
Cap_compensation_1 outfirststage out
.end two_stage_single_output_op_amp152
