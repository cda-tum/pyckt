.suckt  two_stage_single_output_op_amp129 ibias in1 in2 out source_nmos source_pmos
M1 net_0 in1 net_1 net_1 nmos
M2 outfirststage in2 net_1 net_1 nmos
M3 net_2 net_2 source_pmos source_pmos pmos
M4 net_0 net_0 net_2 net_2 pmos
M5 net_3 net_2 source_pmos source_pmos pmos
M6 outfirststage net_0 net_3 net_3 pmos
M7 net_1 ibias source_nmos source_nmos nmos
M8 out outfirststage source_pmos source_pmos pmos
M9 net_5 net_5 source_nmos source_nmos nmos
M10 out net_6 net_5 net_5 nmos
M11 net_6 net_6 bias_n_1m bias_n_1m nmos
M12 bias_n_1m net_5 source_nmos source_nmos nmos
M13 ibias ibias source_nmos source_nmos nmos
M14 bias_p_3 bias_p_3 source_pmos source_pmos pmos
M15 net_6 bias_p_3 source_pmos source_pmos pmos
M16 bias_p_3 ibias source_nmos source_nmos nmos
Cap_load_1 out source_nmos
Cap_compensation_1 outfirststage out
.end two_stage_single_output_op_amp129
