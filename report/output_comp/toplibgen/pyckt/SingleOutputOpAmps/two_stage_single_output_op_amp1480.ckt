.suckt  two_stage_single_output_op_amp1480 ibias in1 in2 out source_nmos source_pmos
M1 net_0 in1 net_1 net_1 nmos
M2 net_2 in2 net_1 net_1 nmos
M3 net_3 net_4 net_0 net_0 nmos
M4 outfirststage net_4 net_2 net_2 nmos
M5 net_5 net_6 source_pmos source_pmos pmos
M6 net_3 net_3 net_5 net_5 pmos
M7 net_6 net_6 source_pmos source_pmos pmos
M8 outfirststage net_3 net_6 net_6 pmos
M9 net_7 net_7 source_nmos source_nmos nmos
M10 net_1 net_8 net_7 net_7 nmos
M11 net_9 bias_p_3b source_pmos source_pmos pmos
M12 out ibias net_9 net_9 pmos
M13 net_12 outfirststage source_nmos source_nmos nmos
M14 out bias_n_2 net_12 net_12 nmos
M15 net_4 net_4 net_1 net_1 nmos
M16 net_8 net_8 bias_n_1m bias_n_1m nmos
M17 bias_n_1m net_7 source_nmos source_nmos nmos
M18 bias_n_2 bias_n_2 source_nmos source_nmos nmos
M19 bias_p_3b bias_p_3b source_pmos source_pmos pmos
M20 ibias ibias bias_p_3b bias_p_3b pmos
M21 net_8 bias_p_3b source_pmos source_pmos pmos
M22 net_4 bias_p_3b source_pmos source_pmos pmos
M23 bias_n_2 bias_p_3b source_pmos source_pmos pmos
Cap_load_1 out source_nmos
Cap_compensation_1 outfirststage out
.end two_stage_single_output_op_amp1480
