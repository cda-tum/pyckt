.suckt  two_stage_single_output_op_amp610 ibias in1 in2 out source_nmos source_pmos
M1 net_0 in1 net_1 net_1 nmos
M2 net_2 in2 net_1 net_1 nmos
M3 net_0 bias_p_3 source_pmos source_pmos pmos
M4 net_4 bias_p_2 net_0 net_0 pmos
M5 net_2 bias_p_3 source_pmos source_pmos pmos
M6 outfirststage bias_p_2 net_2 net_2 pmos
M7 net_4 net_6 source_nmos source_nmos nmos
M8 net_6 net_6 source_nmos source_nmos nmos
M9 outfirststage net_4 net_6 net_6 nmos
M10 net_1 ibias source_nmos source_nmos nmos
M11 net_8 outfirststage source_pmos source_pmos pmos
M12 out bias_p_2 net_8 net_8 pmos
M13 out ibias source_nmos source_nmos nmos
M14 ibias ibias source_nmos source_nmos nmos
M15 bias_p_2 bias_p_2 source_pmos source_pmos pmos
M16 bias_p_3 bias_p_3 source_pmos source_pmos pmos
M17 bias_p_3 ibias source_nmos source_nmos nmos
M18 bias_p_2 ibias source_nmos source_nmos nmos
Cap_load_1 out source_nmos
Cap_compensation_1 outfirststage out
.end two_stage_single_output_op_amp610
