.suckt  two_stage_single_output_op_amp2244 ibias in1 in2 out source_nmos source_pmos
M1 net_0 in1 net_1 net_1 nmos
M2 outfirststage in2 net_1 net_1 nmos
M3 net_0 net_2 source_nmos source_nmos nmos
M4 net_2 net_2 source_nmos source_nmos nmos
M5 outfirststage net_0 net_2 net_2 nmos
M6 net_0 bias_p_4 source_pmos source_pmos pmos
M7 outfirststage bias_p_4 source_pmos source_pmos pmos
M8 net_4 bias_n_2b source_nmos source_nmos nmos
M9 net_1 ibias net_4 net_4 nmos
M10 net_7 outfirststage source_pmos source_pmos pmos
M11 out bias_p_3 net_7 net_7 pmos
M12 net_9 net_9 source_nmos source_nmos nmos
M13 out net_10 net_9 net_9 nmos
M14 net_10 net_10 bias_n_1m bias_n_1m nmos
M15 bias_n_1m net_9 source_nmos source_nmos nmos
M16 bias_n_2b bias_n_2b source_nmos source_nmos nmos
M17 ibias ibias bias_n_2b bias_n_2b nmos
M18 bias_p_3 bias_p_3 source_pmos source_pmos pmos
M19 bias_p_4 bias_p_4 source_pmos source_pmos pmos
M20 bias_p_4 bias_n_2b source_nmos source_nmos nmos
M21 bias_p_3 bias_n_2b source_nmos source_nmos nmos
M22 net_10 bias_p_4 source_pmos source_pmos pmos
Cap_load_1 out source_nmos
Cap_compensation_1 outfirststage out
.end two_stage_single_output_op_amp2244
