.suckt  two_stage_single_output_op_amp1851 ibias in1 in2 out source_nmos source_pmos
M1 net_0 in1 net_1 net_1 pmos
M2 outfirststage in2 net_1 net_1 pmos
M3 net_0 net_0 source_pmos source_pmos pmos
M4 outfirststage net_0 source_pmos source_pmos pmos
M5 net_0 bias_n_1 source_nmos source_nmos nmos
M6 outfirststage bias_n_1 source_nmos source_nmos nmos
M7 net_3 bias_p_2b source_pmos source_pmos pmos
M8 net_1 ibias net_3 net_3 pmos
M9 net_6 bias_p_2b source_pmos source_pmos pmos
M10 out ibias net_6 net_6 pmos
M11 out outfirststage source_nmos source_nmos nmos
M12 bias_n_1 bias_n_1 source_nmos source_nmos nmos
M13 bias_p_2b bias_p_2b source_pmos source_pmos pmos
M14 ibias ibias bias_p_2b bias_p_2b pmos
M15 bias_n_1 bias_p_2b source_pmos source_pmos pmos
Cap_load_1 out source_nmos
Cap_compensation_1 outfirststage out
.end two_stage_single_output_op_amp1851
