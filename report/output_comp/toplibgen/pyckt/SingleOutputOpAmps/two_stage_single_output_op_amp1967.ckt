.suckt  two_stage_single_output_op_amp1967 ibias in1 in2 out source_nmos source_pmos
M1 net_0 in1 net_1 net_1 pmos
M2 outfirststage in2 net_1 net_1 pmos
M3 net_0 net_0 source_pmos source_pmos pmos
M4 net_2 net_0 source_pmos source_pmos pmos
M5 outfirststage bias_p_4 net_2 net_2 pmos
M6 net_0 bias_n_2 source_nmos source_nmos nmos
M7 outfirststage bias_n_2 source_nmos source_nmos nmos
M8 net_5 net_5 source_pmos source_pmos pmos
M9 net_1 ibias net_5 net_5 pmos
M10 net_7 outfirststage source_pmos source_pmos pmos
M11 out bias_p_4 net_7 net_7 pmos
M12 net_9 bias_n_2 source_nmos source_nmos nmos
M13 out bias_n_1 net_9 net_9 nmos
M14 bias_n_1 bias_n_1 source_nmos source_nmos nmos
M15 bias_n_2 bias_n_2 source_nmos source_nmos nmos
M16 ibias ibias bias_p_3m bias_p_3m pmos
M17 bias_p_3m net_5 source_pmos source_pmos pmos
M18 bias_p_4 bias_p_4 source_pmos source_pmos pmos
M19 bias_n_2 net_5 source_pmos source_pmos pmos
M20 bias_n_1 net_5 source_pmos source_pmos pmos
M21 bias_p_4 bias_n_2 source_nmos source_nmos nmos
Cap_load_1 out source_nmos
Cap_compensation_1 outfirststage out
.end two_stage_single_output_op_amp1967
