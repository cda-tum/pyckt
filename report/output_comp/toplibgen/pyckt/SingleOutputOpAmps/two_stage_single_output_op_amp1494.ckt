.suckt  two_stage_single_output_op_amp1494 ibias in1 in2 out source_nmos source_pmos
M1 net_0 in1 net_1 net_1 nmos
M2 net_2 in2 net_1 net_1 nmos
M3 net_3 net_4 net_0 net_0 nmos
M4 outfirststage net_4 net_2 net_2 nmos
M5 net_5 net_3 source_pmos source_pmos pmos
M6 net_3 net_3 net_5 net_5 pmos
M7 net_6 net_3 source_pmos source_pmos pmos
M8 outfirststage net_3 net_6 net_6 pmos
M9 net_7 bias_n_2 source_nmos source_nmos nmos
M10 net_1 bias_n_1 net_7 net_7 nmos
M11 net_10 net_10 source_pmos source_pmos pmos
M12 out ibias net_10 net_10 pmos
M13 net_12 outfirststage source_nmos source_nmos nmos
M14 out bias_n_1 net_12 net_12 nmos
M15 net_4 net_4 net_1 net_1 nmos
M16 bias_n_1 bias_n_1 source_nmos source_nmos nmos
M17 bias_n_2 bias_n_2 source_nmos source_nmos nmos
M18 ibias ibias bias_p_3m bias_p_3m pmos
M19 bias_p_3m net_10 source_pmos source_pmos pmos
M20 bias_n_2 net_10 source_pmos source_pmos pmos
M21 net_4 net_10 source_pmos source_pmos pmos
M22 bias_n_1 net_10 source_pmos source_pmos pmos
Cap_load_1 out source_nmos
Cap_compensation_1 outfirststage out
.end two_stage_single_output_op_amp1494
