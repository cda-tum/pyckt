.suckt  one_stage_single_output_op_amp40 ibias in1 in2 out source_nmos source_pmos
M1 net_0 in1 net_1 net_1 nmos
M2 out in2 net_1 net_1 nmos
M3 net_2 net_3 source_pmos source_pmos pmos
M4 net_0 net_0 net_2 net_2 pmos
M5 net_3 net_3 source_pmos source_pmos pmos
M6 out net_0 net_3 net_3 pmos
M7 net_4 net_4 source_nmos source_nmos nmos
M8 net_1 ibias net_4 net_4 nmos
M9 ibias ibias bias_n_1m bias_n_1m nmos
M10 bias_n_1m net_4 source_nmos source_nmos nmos
Cap_load_1 out source_nmos
.end one_stage_single_output_op_amp40
