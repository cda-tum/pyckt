.suckt  two_stage_single_output_op_amp956 ibias in1 in2 out source_nmos source_pmos
M1 net_0 in1 net_1 net_1 nmos
M2 net_2 in2 net_1 net_1 nmos
M3 net_0 bias_p_4b source_pmos source_pmos pmos
M4 net_4 ibias net_0 net_0 pmos
M5 net_2 bias_p_4b source_pmos source_pmos pmos
M6 outfirststage ibias net_2 net_2 pmos
M7 net_6 net_4 source_nmos source_nmos nmos
M8 net_4 bias_n_2 net_6 net_6 nmos
M9 net_8 net_4 source_nmos source_nmos nmos
M10 outfirststage bias_n_2 net_8 net_8 nmos
M11 net_9 net_9 source_nmos source_nmos nmos
M12 net_1 net_10 net_9 net_9 nmos
M13 out outfirststage source_pmos source_pmos pmos
M14 net_11 bias_n_3 source_nmos source_nmos nmos
M15 out bias_n_2 net_11 net_11 nmos
M16 net_10 net_10 bias_n_1m bias_n_1m nmos
M17 bias_n_1m net_9 source_nmos source_nmos nmos
M18 bias_n_2 bias_n_2 source_nmos source_nmos nmos
M19 bias_n_3 bias_n_3 source_nmos source_nmos nmos
M20 bias_p_4b bias_p_4b source_pmos source_pmos pmos
M21 ibias ibias bias_p_4b bias_p_4b pmos
M22 bias_n_3 bias_p_4b source_pmos source_pmos pmos
M23 bias_n_2 bias_p_4b source_pmos source_pmos pmos
M24 net_10 bias_p_4b source_pmos source_pmos pmos
Cap_load_1 out source_nmos
Cap_compensation_1 outfirststage out
.end two_stage_single_output_op_amp956
