.suckt  symmetrical_op_amp82 ibias in1 in2 out source_nmos source_pmos
M1 out1fs in1 net_0 net_0 nmos
M2 out2fs in2 net_0 net_0 nmos
M3 out1fs out1fs source_pmos source_pmos pmos
M4 out2fs out2fs source_pmos source_pmos pmos
M5 net_1 net_1 source_nmos source_nmos nmos
M6 net_0 ibias net_1 net_1 nmos
M7 net_3 out1fs source_pmos source_pmos pmos
M8 out bias_p_2 net_3 net_3 pmos
M9 net_4 inoutputstagebias source_nmos source_nmos nmos
M10 out inoutputstagebias net_4 net_4 nmos
M11 net_5 out2fs source_pmos source_pmos pmos
M12 inoutputstagebias bias_p_2 net_5 net_5 pmos
M13 net_6 inoutputstagebias source_nmos source_nmos nmos
M14 inoutputstagebias inoutputstagebias net_6 net_6 nmos
M15 ibias ibias bias_n_1m bias_n_1m nmos
M16 bias_n_1m net_1 source_nmos source_nmos nmos
M17 bias_p_2 bias_p_2 source_pmos source_pmos pmos
M18 bias_p_2 net_1 source_nmos source_nmos nmos
Cap_load_1 out source_nmos
.end symmetrical_op_amp82
