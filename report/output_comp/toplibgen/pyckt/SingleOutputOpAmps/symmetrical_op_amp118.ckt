.suckt  symmetrical_op_amp118 ibias in1 in2 out source_nmos source_pmos
M1 out1fs in1 net_0 net_0 nmos
M2 insourcetc in2 net_0 net_0 nmos
M3 net_1 out1fs source_pmos source_pmos pmos
M4 out1fs bias_p_2 net_1 net_1 pmos
M5 net_2 insourcetc source_pmos source_pmos pmos
M6 insourcetc bias_p_2 net_2 net_2 pmos
M7 net_0 ibias source_nmos source_nmos nmos
M8 net_4 out1fs source_pmos source_pmos pmos
M9 out bias_p_2 net_4 net_4 pmos
M10 instagebias instagebias source_nmos source_nmos nmos
M11 out innercomp instagebias instagebias nmos
M12 net_5 insourcetc source_pmos source_pmos pmos
M13 innercomp bias_p_2 net_5 net_5 pmos
M14 innercomp instagebias source_nmos source_nmos nmos
M15 ibias ibias source_nmos source_nmos nmos
M16 bias_p_2 bias_p_2 source_pmos source_pmos pmos
M17 bias_p_2 ibias source_nmos source_nmos nmos
Cap_load_1 out source_nmos
.end symmetrical_op_amp118
