.suckt  two_stage_single_output_op_amp2014 ibias in1 in2 out source_nmos source_pmos
M1 net_0 in1 net_1 net_1 pmos
M2 outfirststage in2 net_1 net_1 pmos
M3 net_2 net_2 source_pmos source_pmos pmos
M4 net_0 net_0 net_2 net_2 pmos
M5 net_3 net_2 source_pmos source_pmos pmos
M6 outfirststage net_0 net_3 net_3 pmos
M7 net_0 ibias source_nmos source_nmos nmos
M8 outfirststage ibias source_nmos source_nmos nmos
M9 net_5 net_5 source_pmos source_pmos pmos
M10 net_1 net_6 net_5 net_5 pmos
M11 net_7 outfirststage source_pmos source_pmos pmos
M12 out bias_p_3 net_7 net_7 pmos
M13 out ibias source_nmos source_nmos nmos
M14 ibias ibias source_nmos source_nmos nmos
M15 net_6 net_6 bias_p_2m bias_p_2m pmos
M16 bias_p_2m net_5 source_pmos source_pmos pmos
M17 bias_p_3 bias_p_3 source_pmos source_pmos pmos
M18 net_6 ibias source_nmos source_nmos nmos
M19 bias_p_3 ibias source_nmos source_nmos nmos
Cap_load_1 out source_nmos
Cap_compensation_1 outfirststage out
.end two_stage_single_output_op_amp2014
