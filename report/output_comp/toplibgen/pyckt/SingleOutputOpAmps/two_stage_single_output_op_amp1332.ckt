.suckt  two_stage_single_output_op_amp1332 ibias in1 in2 out source_nmos source_pmos
M1 net_0 in1 net_1 net_1 pmos
M2 net_2 in2 net_1 net_1 pmos
M3 net_3 net_4 net_0 net_0 pmos
M4 outfirststage net_4 net_2 net_2 pmos
M5 net_5 net_3 source_nmos source_nmos nmos
M6 net_3 net_3 net_5 net_5 nmos
M7 net_6 net_3 source_nmos source_nmos nmos
M8 outfirststage net_3 net_6 net_6 nmos
M9 net_7 bias_p_3 source_pmos source_pmos pmos
M10 net_1 bias_p_2 net_7 net_7 pmos
M11 net_10 outfirststage source_pmos source_pmos pmos
M12 out bias_p_2 net_10 net_10 pmos
M13 net_12 net_12 source_nmos source_nmos nmos
M14 out ibias net_12 net_12 nmos
M15 ibias ibias bias_n_1m bias_n_1m nmos
M16 bias_n_1m net_12 source_nmos source_nmos nmos
M17 net_4 net_4 net_1 net_1 pmos
M18 bias_p_2 bias_p_2 source_pmos source_pmos pmos
M19 bias_p_3 bias_p_3 source_pmos source_pmos pmos
M20 bias_p_3 net_12 source_nmos source_nmos nmos
M21 net_4 net_12 source_nmos source_nmos nmos
M22 bias_p_2 net_12 source_nmos source_nmos nmos
Cap_load_1 out source_nmos
Cap_compensation_1 outfirststage out
.end two_stage_single_output_op_amp1332
