.suckt  two_stage_single_output_op_amp2321 ibias in1 in2 out source_nmos source_pmos
M1 net_0 in1 net_1 net_1 nmos
M2 outfirststage in2 net_1 net_1 nmos
M3 net_0 net_0 source_nmos source_nmos nmos
M4 net_2 net_0 source_nmos source_nmos nmos
M5 outfirststage bias_n_2 net_2 net_2 nmos
M6 net_4 bias_p_4b source_pmos source_pmos pmos
M7 net_0 bias_p_4t net_4 net_4 pmos
M8 net_7 bias_p_4b source_pmos source_pmos pmos
M9 outfirststage bias_p_4t net_7 net_7 pmos
M10 net_8 net_8 source_nmos source_nmos nmos
M11 net_1 ibias net_8 net_8 nmos
M12 net_10 net_10 source_pmos source_pmos pmos
M13 out net_11 net_10 net_10 pmos
M14 out outfirststage source_nmos source_nmos nmos
M15 ibias ibias bias_n_1m bias_n_1m nmos
M16 bias_n_1m net_8 source_nmos source_nmos nmos
M17 bias_n_2 bias_n_2 source_nmos source_nmos nmos
M18 net_11 net_11 bias_p_3m bias_p_3m pmos
M19 bias_p_3m net_10 source_pmos source_pmos pmos
M20 bias_p_4b bias_p_4b source_pmos source_pmos pmos
M21 bias_p_4t bias_p_4t bias_p_4b bias_p_4b pmos
M22 bias_p_4t net_8 source_nmos source_nmos nmos
M23 bias_n_2 bias_p_4b source_pmos source_pmos pmos
M24 net_11 net_8 source_nmos source_nmos nmos
Cap_load_1 out source_nmos
Cap_compensation_1 outfirststage out
.end two_stage_single_output_op_amp2321
