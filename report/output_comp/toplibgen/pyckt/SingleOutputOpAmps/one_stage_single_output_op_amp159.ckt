.suckt  one_stage_single_output_op_amp159 ibias in1 in2 out source_nmos source_pmos
M1 net_0 in1 net_1 net_1 pmos
M2 out in2 net_1 net_1 pmos
M3 net_0 net_2 source_pmos source_pmos pmos
M4 net_2 net_2 source_pmos source_pmos pmos
M5 out net_0 net_2 net_2 pmos
M6 net_0 bias_n_1 source_nmos source_nmos nmos
M7 out bias_n_1 source_nmos source_nmos nmos
M8 net_4 bias_p_2b source_pmos source_pmos pmos
M9 net_1 ibias net_4 net_4 pmos
M10 bias_n_1 bias_n_1 source_nmos source_nmos nmos
M11 bias_p_2b bias_p_2b source_pmos source_pmos pmos
M12 ibias ibias bias_p_2b bias_p_2b pmos
M13 bias_n_1 bias_p_2b source_pmos source_pmos pmos
Cap_load_1 out source_nmos
.end one_stage_single_output_op_amp159
