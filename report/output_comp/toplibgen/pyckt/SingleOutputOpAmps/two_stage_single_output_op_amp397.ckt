.suckt  two_stage_single_output_op_amp397 ibias in1 in2 out source_nmos source_pmos
M1 net_0 in1 net_1 net_1 nmos
M2 outfirststage in2 net_1 net_1 nmos
M3 net_0 net_0 source_pmos source_pmos pmos
M4 net_2 net_0 source_pmos source_pmos pmos
M5 outfirststage bias_p_2 net_2 net_2 pmos
M6 net_4 net_4 source_nmos source_nmos nmos
M7 net_1 ibias net_4 net_4 nmos
M8 out bias_p_3 source_pmos source_pmos pmos
M9 out outfirststage source_nmos source_nmos nmos
M10 ibias ibias bias_n_1m bias_n_1m nmos
M11 bias_n_1m net_4 source_nmos source_nmos nmos
M12 bias_p_2 bias_p_2 source_pmos source_pmos pmos
M13 bias_p_3 bias_p_3 source_pmos source_pmos pmos
M14 bias_p_3 net_4 source_nmos source_nmos nmos
M15 bias_p_2 net_4 source_nmos source_nmos nmos
Cap_load_1 out source_nmos
Cap_compensation_1 outfirststage out
.end two_stage_single_output_op_amp397
