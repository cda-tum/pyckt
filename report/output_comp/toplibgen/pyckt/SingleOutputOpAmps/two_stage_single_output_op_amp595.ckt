.suckt  two_stage_single_output_op_amp595 ibias in1 in2 out source_nmos source_pmos
M1 net_0 in1 net_1 net_1 nmos
M2 net_2 in2 net_1 net_1 nmos
M3 net_0 bias_p_2b source_pmos source_pmos pmos
M4 net_4 bias_p_2t net_0 net_0 pmos
M5 net_2 bias_p_2b source_pmos source_pmos pmos
M6 outfirststage bias_p_2t net_2 net_2 pmos
M7 net_4 net_4 source_nmos source_nmos nmos
M8 outfirststage net_4 source_nmos source_nmos nmos
M9 net_1 ibias source_nmos source_nmos nmos
M10 out outfirststage source_pmos source_pmos pmos
M11 out ibias source_nmos source_nmos nmos
M12 ibias ibias source_nmos source_nmos nmos
M13 bias_p_2b bias_p_2b source_pmos source_pmos pmos
M14 bias_p_2t bias_p_2t bias_p_2b bias_p_2b pmos
M15 bias_p_2t ibias source_nmos source_nmos nmos
Cap_load_1 out source_nmos
Cap_compensation_1 outfirststage out
.end two_stage_single_output_op_amp595
