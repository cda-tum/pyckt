.suckt  two_stage_single_output_op_amp895 ibias in1 in2 out source_nmos source_pmos
M1 net_0 in1 net_1 net_1 nmos
M2 net_2 in2 net_1 net_1 nmos
M3 net_0 bias_p_3b source_pmos source_pmos pmos
M4 net_4 ibias net_0 net_0 pmos
M5 net_2 bias_p_3b source_pmos source_pmos pmos
M6 outfirststage ibias net_2 net_2 pmos
M7 net_4 net_4 source_nmos source_nmos nmos
M8 net_6 net_4 source_nmos source_nmos nmos
M9 outfirststage bias_n_1 net_6 net_6 nmos
M10 net_8 bias_n_2 source_nmos source_nmos nmos
M11 net_1 bias_n_1 net_8 net_8 nmos
M12 out outfirststage source_pmos source_pmos pmos
M13 out bias_n_2 source_nmos source_nmos nmos
M14 bias_n_1 bias_n_1 source_nmos source_nmos nmos
M15 bias_n_2 bias_n_2 source_nmos source_nmos nmos
M16 bias_p_3b bias_p_3b source_pmos source_pmos pmos
M17 ibias ibias bias_p_3b bias_p_3b pmos
M18 bias_n_2 bias_p_3b source_pmos source_pmos pmos
M19 bias_n_1 bias_p_3b source_pmos source_pmos pmos
Cap_load_1 out source_nmos
Cap_compensation_1 outfirststage out
.end two_stage_single_output_op_amp895
