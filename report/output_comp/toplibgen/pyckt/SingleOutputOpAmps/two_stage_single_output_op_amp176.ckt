.suckt  two_stage_single_output_op_amp176 ibias in1 in2 out source_nmos source_pmos
M1 net_0 in1 net_1 net_1 pmos
M2 outfirststage in2 net_1 net_1 pmos
M3 net_0 net_0 source_nmos source_nmos nmos
M4 outfirststage net_0 source_nmos source_nmos nmos
M5 net_2 bias_p_2b source_pmos source_pmos pmos
M6 net_1 ibias net_2 net_2 pmos
M7 out outfirststage source_pmos source_pmos pmos
M8 net_5 bias_n_1b source_nmos source_nmos nmos
M9 out bias_n_1t net_5 net_5 nmos
M10 bias_n_1b bias_n_1b source_nmos source_nmos nmos
M11 bias_n_1t bias_n_1t bias_n_1b bias_n_1b nmos
M12 bias_p_2b bias_p_2b source_pmos source_pmos pmos
M13 ibias ibias bias_p_2b bias_p_2b pmos
M14 bias_n_1t bias_p_2b source_pmos source_pmos pmos
Cap_load_1 out source_nmos
Cap_compensation_1 outfirststage out
.end two_stage_single_output_op_amp176
