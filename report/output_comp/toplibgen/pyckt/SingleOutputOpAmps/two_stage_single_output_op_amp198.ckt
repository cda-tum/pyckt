.suckt  two_stage_single_output_op_amp198 ibias in1 in2 out source_nmos source_pmos
M1 net_0 in1 net_1 net_1 pmos
M2 outfirststage in2 net_1 net_1 pmos
M3 net_0 net_2 source_nmos source_nmos nmos
M4 net_2 net_2 source_nmos source_nmos nmos
M5 outfirststage net_0 net_2 net_2 nmos
M6 net_3 bias_p_3b source_pmos source_pmos pmos
M7 net_1 ibias net_3 net_3 pmos
M8 net_6 net_6 source_pmos source_pmos pmos
M9 out net_7 net_6 net_6 pmos
M10 net_8 outfirststage source_nmos source_nmos nmos
M11 out bias_n_1 net_8 net_8 nmos
M12 bias_n_1 bias_n_1 source_nmos source_nmos nmos
M13 net_7 net_7 bias_p_2m bias_p_2m pmos
M14 bias_p_2m net_6 source_pmos source_pmos pmos
M15 bias_p_3b bias_p_3b source_pmos source_pmos pmos
M16 ibias ibias bias_p_3b bias_p_3b pmos
M17 bias_n_4 bias_n_4 source_nmos source_nmos nmos
M18 bias_n_1 bias_p_3b source_pmos source_pmos pmos
M19 net_7 bias_n_4 source_nmos source_nmos nmos
M20 bias_n_4 bias_p_3b source_pmos source_pmos pmos
Cap_load_1 out source_nmos
Cap_compensation_1 outfirststage out
.end two_stage_single_output_op_amp198
