.suckt  two_stage_single_output_op_amp2415 ibias in1 in2 out source_nmos source_pmos
M1 net_0 in1 net_1 net_1 nmos
M2 outfirststage in2 net_1 net_1 nmos
M3 net_2 net_0 source_nmos source_nmos nmos
M4 net_0 bias_n_2 net_2 net_2 nmos
M5 net_4 net_0 source_nmos source_nmos nmos
M6 outfirststage bias_n_2 net_4 net_4 nmos
M7 net_5 bias_p_3b source_pmos source_pmos pmos
M8 net_0 ibias net_5 net_5 pmos
M9 net_8 bias_p_3b source_pmos source_pmos pmos
M10 outfirststage ibias net_8 net_8 pmos
M11 net_9 net_9 source_nmos source_nmos nmos
M12 net_1 net_10 net_9 net_9 nmos
M13 net_11 bias_p_3b source_pmos source_pmos pmos
M14 out ibias net_11 net_11 pmos
M15 out outfirststage source_nmos source_nmos nmos
M16 net_10 net_10 bias_n_1m bias_n_1m nmos
M17 bias_n_1m net_9 source_nmos source_nmos nmos
M18 bias_n_2 bias_n_2 source_nmos source_nmos nmos
M19 bias_p_3b bias_p_3b source_pmos source_pmos pmos
M20 ibias ibias bias_p_3b bias_p_3b pmos
M21 net_10 bias_p_3b source_pmos source_pmos pmos
M22 bias_n_2 bias_p_3b source_pmos source_pmos pmos
Cap_load_1 out source_nmos
Cap_compensation_1 outfirststage out
.end two_stage_single_output_op_amp2415
