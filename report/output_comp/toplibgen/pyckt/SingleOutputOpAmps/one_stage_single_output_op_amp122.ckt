.suckt  one_stage_single_output_op_amp122 ibias in1 in2 out source_nmos source_pmos
M1 net_0 in1 net_1 net_1 nmos
M2 net_2 in2 net_1 net_1 nmos
M3 net_3 net_4 net_0 net_0 nmos
M4 out net_4 net_2 net_2 nmos
M5 net_5 net_3 source_pmos source_pmos pmos
M6 net_3 bias_p_2 net_5 net_5 pmos
M7 net_7 net_3 source_pmos source_pmos pmos
M8 out bias_p_2 net_7 net_7 pmos
M9 net_8 net_8 source_nmos source_nmos nmos
M10 net_1 ibias net_8 net_8 nmos
M11 net_4 net_4 net_1 net_1 nmos
M12 ibias ibias bias_n_1m bias_n_1m nmos
M13 bias_n_1m net_8 source_nmos source_nmos nmos
M14 bias_p_2 bias_p_2 source_pmos source_pmos pmos
M15 bias_p_3 bias_p_3 source_pmos source_pmos pmos
M16 net_4 bias_p_3 source_pmos source_pmos pmos
M17 bias_p_2 net_8 source_nmos source_nmos nmos
M18 bias_p_3 net_8 source_nmos source_nmos nmos
Cap_load_1 out source_nmos
.end one_stage_single_output_op_amp122
