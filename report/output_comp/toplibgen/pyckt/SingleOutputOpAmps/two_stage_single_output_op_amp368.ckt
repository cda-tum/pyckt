.suckt  two_stage_single_output_op_amp368 ibias in1 in2 out source_nmos source_pmos
M1 net_0 in1 net_1 net_1 nmos
M2 outfirststage in2 net_1 net_1 nmos
M3 net_0 net_2 source_pmos source_pmos pmos
M4 net_2 net_2 source_pmos source_pmos pmos
M5 outfirststage net_0 net_2 net_2 pmos
M6 net_3 bias_n_1b source_nmos source_nmos nmos
M7 net_1 ibias net_3 net_3 nmos
M8 out outfirststage source_pmos source_pmos pmos
M9 net_6 bias_n_1b source_nmos source_nmos nmos
M10 out ibias net_6 net_6 nmos
M11 bias_n_1b bias_n_1b source_nmos source_nmos nmos
M12 ibias ibias bias_n_1b bias_n_1b nmos
Cap_load_1 out source_nmos
Cap_compensation_1 outfirststage out
.end two_stage_single_output_op_amp368
