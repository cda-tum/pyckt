.suckt  symmetrical_op_amp25 ibias in1 in2 out source_nmos source_pmos
M1 out1fs in1 net_0 net_0 nmos
M2 out2fs in2 net_0 net_0 nmos
M3 out1fs out1fs source_pmos source_pmos pmos
M4 out2fs out2fs source_pmos source_pmos pmos
M5 net_0 ibias source_nmos source_nmos nmos
M6 net_2 out1fs source_pmos source_pmos pmos
M7 out bias_p_3 net_2 net_2 pmos
M8 net_3 insourcestagebias source_nmos source_nmos nmos
M9 out bias_n_1 net_3 net_3 nmos
M10 net_4 out2fs source_pmos source_pmos pmos
M11 insourcestagebias bias_p_3 net_4 net_4 pmos
M12 net_5 insourcestagebias source_nmos source_nmos nmos
M13 insourcestagebias bias_n_1 net_5 net_5 nmos
M14 bias_n_1 bias_n_1 source_nmos source_nmos nmos
M15 ibias ibias source_nmos source_nmos nmos
M16 bias_p_3 bias_p_3 source_pmos source_pmos pmos
M17 bias_p_4 bias_p_4 source_pmos source_pmos pmos
M18 bias_n_1 bias_p_4 source_pmos source_pmos pmos
M19 bias_p_3 ibias source_nmos source_nmos nmos
M20 bias_p_4 ibias source_nmos source_nmos nmos
Cap_load_1 out source_nmos
.end symmetrical_op_amp25
