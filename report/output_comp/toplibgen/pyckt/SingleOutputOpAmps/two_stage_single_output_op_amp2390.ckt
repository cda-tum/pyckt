.suckt  two_stage_single_output_op_amp2390 ibias in1 in2 out source_nmos source_pmos
M1 net_0 in1 net_1 net_1 nmos
M2 outfirststage in2 net_1 net_1 nmos
M3 net_2 net_0 source_nmos source_nmos nmos
M4 net_0 bias_n_2 net_2 net_2 nmos
M5 net_4 net_0 source_nmos source_nmos nmos
M6 outfirststage bias_n_2 net_4 net_4 nmos
M7 net_0 ibias source_pmos source_pmos pmos
M8 outfirststage ibias source_pmos source_pmos pmos
M9 net_6 net_6 source_nmos source_nmos nmos
M10 net_1 net_7 net_6 net_6 nmos
M11 out ibias source_pmos source_pmos pmos
M12 net_9 outfirststage source_nmos source_nmos nmos
M13 out bias_n_2 net_9 net_9 nmos
M14 net_7 net_7 bias_n_1m bias_n_1m nmos
M15 bias_n_1m net_6 source_nmos source_nmos nmos
M16 bias_n_2 bias_n_2 source_nmos source_nmos nmos
M17 ibias ibias source_pmos source_pmos pmos
M18 net_7 ibias source_pmos source_pmos pmos
M19 bias_n_2 ibias source_pmos source_pmos pmos
Cap_load_1 out source_nmos
Cap_compensation_1 outfirststage out
.end two_stage_single_output_op_amp2390
