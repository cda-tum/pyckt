.suckt  symmetrical_op_amp151 ibias in1 in2 out source_nmos source_pmos
M1 out1fs in1 net_0 net_0 pmos
M2 insourcetc in2 net_0 net_0 pmos
M3 net_1 out1fs source_nmos source_nmos nmos
M4 out1fs bias_n_1 net_1 net_1 nmos
M5 net_2 insourcetc source_nmos source_nmos nmos
M6 insourcetc bias_n_1 net_2 net_2 nmos
M7 net_3 net_3 source_pmos source_pmos pmos
M8 net_0 ibias net_3 net_3 pmos
M9 net_5 insourcestagebias source_pmos source_pmos pmos
M10 out bias_p_3 net_5 net_5 pmos
M11 net_6 out1fs source_nmos source_nmos nmos
M12 out bias_n_1 net_6 net_6 nmos
M13 net_7 insourcetc source_nmos source_nmos nmos
M14 insourcestagebias bias_n_1 net_7 net_7 nmos
M15 net_8 insourcestagebias source_pmos source_pmos pmos
M16 insourcestagebias bias_p_3 net_8 net_8 pmos
M17 bias_n_1 bias_n_1 source_nmos source_nmos nmos
M18 ibias ibias bias_p_2m bias_p_2m pmos
M19 bias_p_2m net_3 source_pmos source_pmos pmos
M20 bias_p_3 bias_p_3 source_pmos source_pmos pmos
M21 bias_n_4 bias_n_4 source_nmos source_nmos nmos
M22 bias_n_1 net_3 source_pmos source_pmos pmos
M23 bias_p_3 bias_n_4 source_nmos source_nmos nmos
M24 bias_n_4 net_3 source_pmos source_pmos pmos
Cap_load_1 out source_nmos
.end symmetrical_op_amp151
