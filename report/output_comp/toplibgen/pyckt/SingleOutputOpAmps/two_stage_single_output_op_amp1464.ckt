.suckt  two_stage_single_output_op_amp1464 ibias in1 in2 out source_nmos source_pmos
M1 net_0 in1 net_1 net_1 nmos
M2 net_2 in2 net_1 net_1 nmos
M3 net_3 net_4 net_0 net_0 nmos
M4 outfirststage net_4 net_2 net_2 nmos
M5 net_5 net_3 source_pmos source_pmos pmos
M6 net_3 bias_p_3 net_5 net_5 pmos
M7 net_7 net_3 source_pmos source_pmos pmos
M8 outfirststage bias_p_3 net_7 net_7 pmos
M9 net_8 net_8 source_nmos source_nmos nmos
M10 net_1 net_9 net_8 net_8 nmos
M11 net_10 outfirststage source_pmos source_pmos pmos
M12 out bias_p_3 net_10 net_10 pmos
M13 net_12 net_12 source_nmos source_nmos nmos
M14 out ibias net_12 net_12 nmos
M15 net_4 net_4 net_1 net_1 nmos
M16 net_9 net_9 bias_n_1m bias_n_1m nmos
M17 bias_n_1m net_8 source_nmos source_nmos nmos
M18 ibias ibias bias_n_2m bias_n_2m nmos
M19 bias_n_2m net_12 source_nmos source_nmos nmos
M20 bias_p_3 bias_p_3 source_pmos source_pmos pmos
M21 bias_p_4 bias_p_4 source_pmos source_pmos pmos
M22 net_4 bias_p_4 source_pmos source_pmos pmos
M23 bias_p_3 net_12 source_nmos source_nmos nmos
M24 net_9 bias_p_4 source_pmos source_pmos pmos
M25 bias_p_4 net_12 source_nmos source_nmos nmos
Cap_load_1 out source_nmos
Cap_compensation_1 outfirststage out
.end two_stage_single_output_op_amp1464
