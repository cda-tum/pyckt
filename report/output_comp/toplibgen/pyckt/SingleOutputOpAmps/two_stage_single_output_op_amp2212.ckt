.suckt  two_stage_single_output_op_amp2212 ibias in1 in2 out source_nmos source_pmos
M1 net_0 in1 net_1 net_1 nmos
M2 outfirststage in2 net_1 net_1 nmos
M3 net_0 net_0 source_nmos source_nmos nmos
M4 outfirststage net_0 source_nmos source_nmos nmos
M5 net_2 bias_p_3b source_pmos source_pmos pmos
M6 net_0 ibias net_2 net_2 pmos
M7 net_5 bias_p_3b source_pmos source_pmos pmos
M8 outfirststage ibias net_5 net_5 pmos
M9 net_6 bias_n_2 source_nmos source_nmos nmos
M10 net_1 bias_n_1 net_6 net_6 nmos
M11 net_9 bias_p_3b source_pmos source_pmos pmos
M12 out ibias net_9 net_9 pmos
M13 net_12 outfirststage source_nmos source_nmos nmos
M14 out bias_n_1 net_12 net_12 nmos
M15 bias_n_1 bias_n_1 source_nmos source_nmos nmos
M16 bias_n_2 bias_n_2 source_nmos source_nmos nmos
M17 bias_p_3b bias_p_3b source_pmos source_pmos pmos
M18 ibias ibias bias_p_3b bias_p_3b pmos
M19 bias_n_2 bias_p_3b source_pmos source_pmos pmos
M20 bias_n_1 bias_p_3b source_pmos source_pmos pmos
Cap_load_1 out source_nmos
Cap_compensation_1 outfirststage out
.end two_stage_single_output_op_amp2212
