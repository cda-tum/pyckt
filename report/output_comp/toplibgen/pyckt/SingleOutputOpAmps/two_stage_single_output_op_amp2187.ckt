.suckt  two_stage_single_output_op_amp2187 ibias in1 in2 out source_nmos source_pmos
M1 net_0 in1 net_1 net_1 nmos
M2 outfirststage in2 net_1 net_1 nmos
M3 net_0 net_0 source_nmos source_nmos nmos
M4 outfirststage net_0 source_nmos source_nmos nmos
M5 net_0 bias_p_3 source_pmos source_pmos pmos
M6 outfirststage bias_p_3 source_pmos source_pmos pmos
M7 net_3 bias_n_1b source_nmos source_nmos nmos
M8 net_1 ibias net_3 net_3 nmos
M9 net_6 bias_p_3 source_pmos source_pmos pmos
M10 out bias_p_2 net_6 net_6 pmos
M11 out outfirststage source_nmos source_nmos nmos
M12 bias_n_1b bias_n_1b source_nmos source_nmos nmos
M13 ibias ibias bias_n_1b bias_n_1b nmos
M14 bias_p_2 bias_p_2 source_pmos source_pmos pmos
M15 bias_p_3 bias_p_3 source_pmos source_pmos pmos
M16 bias_p_3 bias_n_1b source_nmos source_nmos nmos
M17 bias_p_2 bias_n_1b source_nmos source_nmos nmos
Cap_load_1 out source_nmos
Cap_compensation_1 outfirststage out
.end two_stage_single_output_op_amp2187
