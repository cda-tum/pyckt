.suckt  two_stage_single_output_op_amp1521 ibias in1 in2 out source_nmos source_pmos
M1 net_0 in1 net_1 net_1 pmos
M2 outfirststage in2 net_1 net_1 pmos
M3 net_0 net_0 source_pmos source_pmos pmos
M4 outfirststage net_0 source_pmos source_pmos pmos
M5 net_0 bias_n_2 source_nmos source_nmos nmos
M6 outfirststage bias_n_2 source_nmos source_nmos nmos
M7 net_1 ibias source_pmos source_pmos pmos
M8 out outfirststage source_pmos source_pmos pmos
M9 net_4 net_4 source_nmos source_nmos nmos
M10 out net_5 net_4 net_4 nmos
M11 net_5 net_5 bias_n_1m bias_n_1m nmos
M12 bias_n_1m net_4 source_nmos source_nmos nmos
M13 bias_n_2 bias_n_2 source_nmos source_nmos nmos
M14 ibias ibias source_pmos source_pmos pmos
M15 bias_n_2 ibias source_pmos source_pmos pmos
M16 net_5 ibias source_pmos source_pmos pmos
Cap_load_1 out source_nmos
Cap_compensation_1 outfirststage out
.end two_stage_single_output_op_amp1521
