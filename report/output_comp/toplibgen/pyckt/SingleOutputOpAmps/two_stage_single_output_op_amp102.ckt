.suckt  two_stage_single_output_op_amp102 ibias in1 in2 out source_nmos source_pmos
M1 net_0 in1 net_1 net_1 nmos
M2 outfirststage in2 net_1 net_1 nmos
M3 net_0 net_2 source_pmos source_pmos pmos
M4 net_2 net_2 source_pmos source_pmos pmos
M5 outfirststage net_0 net_2 net_2 pmos
M6 net_1 bias_n_2 source_nmos source_nmos nmos
M7 net_4 net_4 source_pmos source_pmos pmos
M8 out ibias net_4 net_4 pmos
M9 net_6 outfirststage source_nmos source_nmos nmos
M10 out bias_n_1 net_6 net_6 nmos
M11 bias_n_1 bias_n_1 source_nmos source_nmos nmos
M12 bias_n_2 bias_n_2 source_nmos source_nmos nmos
M13 ibias ibias bias_p_3m bias_p_3m pmos
M14 bias_p_3m net_4 source_pmos source_pmos pmos
M15 bias_n_2 net_4 source_pmos source_pmos pmos
M16 bias_n_1 net_4 source_pmos source_pmos pmos
Cap_load_1 out source_nmos
Cap_compensation_1 outfirststage out
.end two_stage_single_output_op_amp102
