.suckt  two_stage_single_output_op_amp438 ibias in1 in2 out source_nmos source_pmos
M1 net_0 in1 net_1 net_1 nmos
M2 outfirststage in2 net_1 net_1 nmos
M3 net_2 net_0 source_pmos source_pmos pmos
M4 net_0 bias_p_4 net_2 net_2 pmos
M5 net_4 net_0 source_pmos source_pmos pmos
M6 outfirststage bias_p_4 net_4 net_4 pmos
M7 net_5 ibias source_nmos source_nmos nmos
M8 net_1 bias_n_1 net_5 net_5 nmos
M9 net_8 net_8 source_pmos source_pmos pmos
M10 out net_9 net_8 net_8 pmos
M11 net_10 outfirststage source_nmos source_nmos nmos
M12 out bias_n_1 net_10 net_10 nmos
M13 bias_n_1 bias_n_1 source_nmos source_nmos nmos
M14 ibias ibias source_nmos source_nmos nmos
M15 net_9 net_9 bias_p_3m bias_p_3m pmos
M16 bias_p_3m net_8 source_pmos source_pmos pmos
M17 bias_p_4 bias_p_4 source_pmos source_pmos pmos
M18 bias_p_5 bias_p_5 source_pmos source_pmos pmos
M19 net_9 ibias source_nmos source_nmos nmos
M20 bias_n_1 bias_p_5 source_pmos source_pmos pmos
M21 bias_p_4 ibias source_nmos source_nmos nmos
M22 bias_p_5 ibias source_nmos source_nmos nmos
Cap_load_1 out source_nmos
Cap_compensation_1 outfirststage out
.end two_stage_single_output_op_amp438
