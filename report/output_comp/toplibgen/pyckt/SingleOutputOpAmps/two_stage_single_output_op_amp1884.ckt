.suckt  two_stage_single_output_op_amp1884 ibias in1 in2 out source_nmos source_pmos
M1 net_0 in1 net_1 net_1 pmos
M2 outfirststage in2 net_1 net_1 pmos
M3 net_0 net_0 source_pmos source_pmos pmos
M4 outfirststage net_0 source_pmos source_pmos pmos
M5 net_2 bias_n_2b source_nmos source_nmos nmos
M6 net_0 bias_n_2t net_2 net_2 nmos
M7 net_5 bias_n_2b source_nmos source_nmos nmos
M8 outfirststage bias_n_2t net_5 net_5 nmos
M9 net_6 ibias source_pmos source_pmos pmos
M10 net_1 bias_p_3 net_6 net_6 pmos
M11 net_9 outfirststage source_pmos source_pmos pmos
M12 out bias_p_3 net_9 net_9 pmos
M13 net_11 net_11 source_nmos source_nmos nmos
M14 out net_12 net_11 net_11 nmos
M15 net_12 net_12 bias_n_1m bias_n_1m nmos
M16 bias_n_1m net_11 source_nmos source_nmos nmos
M17 bias_n_2b bias_n_2b source_nmos source_nmos nmos
M18 bias_n_2t bias_n_2t bias_n_2b bias_n_2b nmos
M19 bias_p_3 bias_p_3 source_pmos source_pmos pmos
M20 ibias ibias source_pmos source_pmos pmos
M21 bias_n_2t ibias source_pmos source_pmos pmos
M22 bias_p_3 bias_n_2b source_nmos source_nmos nmos
M23 net_12 ibias source_pmos source_pmos pmos
Cap_load_1 out source_nmos
Cap_compensation_1 outfirststage out
.end two_stage_single_output_op_amp1884
