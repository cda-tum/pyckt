.suckt  two_stage_single_output_op_amp1695 ibias in1 in2 out source_nmos source_pmos
M1 net_0 in1 net_1 net_1 nmos
M2 outfirststage in2 net_1 net_1 nmos
M3 net_0 net_0 source_nmos source_nmos nmos
M4 outfirststage net_0 source_nmos source_nmos nmos
M5 net_2 bias_p_2b source_pmos source_pmos pmos
M6 net_0 bias_p_2t net_2 net_2 pmos
M7 net_5 bias_p_2b source_pmos source_pmos pmos
M8 outfirststage bias_p_2t net_5 net_5 pmos
M9 net_1 ibias source_nmos source_nmos nmos
M10 net_7 bias_p_2b source_pmos source_pmos pmos
M11 out bias_p_2t net_7 net_7 pmos
M12 out outfirststage source_nmos source_nmos nmos
M13 ibias ibias source_nmos source_nmos nmos
M14 bias_p_2b bias_p_2b source_pmos source_pmos pmos
M15 bias_p_2t bias_p_2t bias_p_2b bias_p_2b pmos
M16 bias_p_2t ibias source_nmos source_nmos nmos
Cap_load_1 out source_nmos
Cap_compensation_1 outfirststage out
.end two_stage_single_output_op_amp1695
