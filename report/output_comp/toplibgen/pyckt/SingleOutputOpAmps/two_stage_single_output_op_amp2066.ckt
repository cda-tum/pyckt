.suckt  two_stage_single_output_op_amp2066 ibias in1 in2 out source_nmos source_pmos
M1 net_0 in1 net_1 net_1 pmos
M2 outfirststage in2 net_1 net_1 pmos
M3 net_2 net_0 source_pmos source_pmos pmos
M4 net_0 bias_p_3 net_2 net_2 pmos
M5 net_4 net_0 source_pmos source_pmos pmos
M6 outfirststage bias_p_3 net_4 net_4 pmos
M7 net_5 bias_n_2 source_nmos source_nmos nmos
M8 net_0 bias_n_1 net_5 net_5 nmos
M9 net_8 bias_n_2 source_nmos source_nmos nmos
M10 outfirststage bias_n_1 net_8 net_8 nmos
M11 net_9 ibias source_pmos source_pmos pmos
M12 net_1 bias_p_3 net_9 net_9 pmos
M13 out ibias source_pmos source_pmos pmos
M14 net_13 outfirststage source_nmos source_nmos nmos
M15 out bias_n_1 net_13 net_13 nmos
M16 bias_n_1 bias_n_1 source_nmos source_nmos nmos
M17 bias_n_2 bias_n_2 source_nmos source_nmos nmos
M18 bias_p_3 bias_p_3 source_pmos source_pmos pmos
M19 ibias ibias source_pmos source_pmos pmos
M20 bias_n_2 ibias source_pmos source_pmos pmos
M21 bias_n_1 ibias source_pmos source_pmos pmos
M22 bias_p_3 bias_n_2 source_nmos source_nmos nmos
Cap_load_1 out source_nmos
Cap_compensation_1 outfirststage out
.end two_stage_single_output_op_amp2066
