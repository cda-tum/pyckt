.suckt  symmetrical_op_amp11 ibias in1 in2 out source_nmos source_pmos
M1 out1fs in1 net_0 net_0 pmos
M2 out2fs in2 net_0 net_0 pmos
M3 out1fs out1fs source_nmos source_nmos nmos
M4 out2fs out2fs source_nmos source_nmos nmos
M5 net_0 ibias source_pmos source_pmos pmos
M6 instagebias instagebias source_pmos source_pmos pmos
M7 out innercomp instagebias instagebias pmos
M8 out out1fs source_nmos source_nmos nmos
M9 innercomp out2fs source_nmos source_nmos nmos
M10 innercomp instagebias source_pmos source_pmos pmos
M11 ibias ibias source_pmos source_pmos pmos
Cap_load_1 out source_nmos
.end symmetrical_op_amp11
