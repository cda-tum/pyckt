.suckt  one_stage_single_output_op_amp5 ibias in1 in2 out source_nmos source_pmos
M1 net_0 in1 net_1 net_1 pmos
M2 out in2 net_1 net_1 pmos
M3 net_2 net_0 source_nmos source_nmos nmos
M4 net_0 bias_n_1 net_2 net_2 nmos
M5 net_4 net_0 source_nmos source_nmos nmos
M6 out bias_n_1 net_4 net_4 nmos
M7 net_1 ibias source_pmos source_pmos pmos
M8 bias_n_1 bias_n_1 source_nmos source_nmos nmos
M9 ibias ibias source_pmos source_pmos pmos
M10 bias_n_1 ibias source_pmos source_pmos pmos
Cap_load_1 out source_nmos
.end one_stage_single_output_op_amp5
