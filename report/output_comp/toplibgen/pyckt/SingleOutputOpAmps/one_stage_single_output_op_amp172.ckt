.suckt  one_stage_single_output_op_amp172 ibias in1 in2 out source_nmos source_pmos
M1 net_0 in1 net_1 net_1 pmos
M2 out in2 net_1 net_1 pmos
M3 net_2 net_0 source_pmos source_pmos pmos
M4 net_0 bias_p_3 net_2 net_2 pmos
M5 net_4 net_0 source_pmos source_pmos pmos
M6 out bias_p_3 net_4 net_4 pmos
M7 net_0 ibias source_nmos source_nmos nmos
M8 out ibias source_nmos source_nmos nmos
M9 net_6 net_6 source_pmos source_pmos pmos
M10 net_1 net_7 net_6 net_6 pmos
M11 ibias ibias source_nmos source_nmos nmos
M12 net_7 net_7 bias_p_2m bias_p_2m pmos
M13 bias_p_2m net_6 source_pmos source_pmos pmos
M14 bias_p_3 bias_p_3 source_pmos source_pmos pmos
M15 net_7 ibias source_nmos source_nmos nmos
M16 bias_p_3 ibias source_nmos source_nmos nmos
Cap_load_1 out source_nmos
.end one_stage_single_output_op_amp172
