.suckt  two_stage_single_output_op_amp2082 ibias in1 in2 out source_nmos source_pmos
M1 net_0 in1 net_1 net_1 pmos
M2 outfirststage in2 net_1 net_1 pmos
M3 net_2 net_0 source_pmos source_pmos pmos
M4 net_0 bias_p_5 net_2 net_2 pmos
M5 net_4 net_0 source_pmos source_pmos pmos
M6 outfirststage bias_p_5 net_4 net_4 pmos
M7 net_5 ibias source_nmos source_nmos nmos
M8 net_0 bias_n_1 net_5 net_5 nmos
M9 net_8 ibias source_nmos source_nmos nmos
M10 outfirststage bias_n_1 net_8 net_8 nmos
M11 net_9 net_9 source_pmos source_pmos pmos
M12 net_1 net_10 net_9 net_9 pmos
M13 net_11 net_11 source_pmos source_pmos pmos
M14 out net_12 net_11 net_11 pmos
M15 net_13 outfirststage source_nmos source_nmos nmos
M16 out bias_n_1 net_13 net_13 nmos
M17 bias_n_1 bias_n_1 source_nmos source_nmos nmos
M18 ibias ibias source_nmos source_nmos nmos
M19 net_10 net_10 bias_p_3m bias_p_3m pmos
M20 bias_p_3m net_9 source_pmos source_pmos pmos
M21 net_12 net_12 bias_p_4m bias_p_4m pmos
M22 bias_p_4m net_11 source_pmos source_pmos pmos
M23 bias_p_5 bias_p_5 source_pmos source_pmos pmos
M24 bias_p_6 bias_p_6 source_pmos source_pmos pmos
M25 net_12 ibias source_nmos source_nmos nmos
M26 bias_n_1 bias_p_6 source_pmos source_pmos pmos
M27 bias_p_5 ibias source_nmos source_nmos nmos
M28 net_10 ibias source_nmos source_nmos nmos
M29 bias_p_6 ibias source_nmos source_nmos nmos
Cap_load_1 out source_nmos
Cap_compensation_1 outfirststage out
.end two_stage_single_output_op_amp2082
