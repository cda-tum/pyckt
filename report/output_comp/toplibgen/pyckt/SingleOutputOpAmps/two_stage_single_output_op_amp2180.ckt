.suckt  two_stage_single_output_op_amp2180 ibias in1 in2 out source_nmos source_pmos
M1 net_0 in1 net_1 net_1 pmos
M2 outfirststage in2 net_1 net_1 pmos
M3 net_2 net_0 source_pmos source_pmos pmos
M4 net_0 net_0 net_2 net_2 pmos
M5 net_3 net_0 source_pmos source_pmos pmos
M6 outfirststage net_0 net_3 net_3 pmos
M7 net_4 bias_n_1b source_nmos source_nmos nmos
M8 net_0 bias_n_1t net_4 net_4 nmos
M9 net_7 bias_n_1b source_nmos source_nmos nmos
M10 outfirststage bias_n_1t net_7 net_7 nmos
M11 net_8 net_8 source_pmos source_pmos pmos
M12 net_1 ibias net_8 net_8 pmos
M13 out outfirststage source_pmos source_pmos pmos
M14 net_10 bias_n_1b source_nmos source_nmos nmos
M15 out bias_n_1t net_10 net_10 nmos
M16 bias_n_1b bias_n_1b source_nmos source_nmos nmos
M17 bias_n_1t bias_n_1t bias_n_1b bias_n_1b nmos
M18 ibias ibias bias_p_2m bias_p_2m pmos
M19 bias_p_2m net_8 source_pmos source_pmos pmos
M20 bias_n_1t net_8 source_pmos source_pmos pmos
Cap_load_1 out source_nmos
Cap_compensation_1 outfirststage out
.end two_stage_single_output_op_amp2180
