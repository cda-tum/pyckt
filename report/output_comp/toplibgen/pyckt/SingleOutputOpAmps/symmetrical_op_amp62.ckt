.suckt  symmetrical_op_amp62 ibias in1 in2 out source_nmos source_pmos
M1 out1fs in1 net_0 net_0 nmos
M2 out2fs in2 net_0 net_0 nmos
M3 out1fs out1fs source_pmos source_pmos pmos
M4 out2fs out2fs source_pmos source_pmos pmos
M5 net_1 bias_n_1b source_nmos source_nmos nmos
M6 net_0 ibias net_1 net_1 nmos
M7 out out1fs source_pmos source_pmos pmos
M8 instagebias instagebias source_nmos source_nmos nmos
M9 out innercomp instagebias instagebias nmos
M10 innercomp out2fs source_pmos source_pmos pmos
M11 innercomp instagebias source_nmos source_nmos nmos
M12 bias_n_1b bias_n_1b source_nmos source_nmos nmos
M13 ibias ibias bias_n_1b bias_n_1b nmos
Cap_load_1 out source_nmos
.end symmetrical_op_amp62
