.suckt  one_stage_single_output_op_amp110 ibias in1 in2 out source_nmos source_pmos
M1 net_0 in1 net_1 net_1 pmos
M2 net_2 in2 net_1 net_1 pmos
M3 net_3 net_4 net_0 net_0 pmos
M4 out net_4 net_2 net_2 pmos
M5 net_5 net_6 source_nmos source_nmos nmos
M6 net_3 net_3 net_5 net_5 nmos
M7 net_6 net_6 source_nmos source_nmos nmos
M8 out net_3 net_6 net_6 nmos
M9 net_7 net_7 source_pmos source_pmos pmos
M10 net_1 ibias net_7 net_7 pmos
M11 net_4 net_4 net_1 net_1 pmos
M12 ibias ibias bias_p_1m bias_p_1m pmos
M13 bias_p_1m net_7 source_pmos source_pmos pmos
M14 bias_n_2 bias_n_2 source_nmos source_nmos nmos
M15 net_4 bias_n_2 source_nmos source_nmos nmos
M16 bias_n_2 net_7 source_pmos source_pmos pmos
Cap_load_1 out source_nmos
.end one_stage_single_output_op_amp110
