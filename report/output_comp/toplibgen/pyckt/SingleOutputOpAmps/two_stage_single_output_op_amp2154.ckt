.suckt  two_stage_single_output_op_amp2154 ibias in1 in2 out source_nmos source_pmos
M1 net_0 in1 net_1 net_1 pmos
M2 outfirststage in2 net_1 net_1 pmos
M3 net_2 net_0 source_pmos source_pmos pmos
M4 net_0 net_0 net_2 net_2 pmos
M5 net_3 net_0 source_pmos source_pmos pmos
M6 outfirststage net_0 net_3 net_3 pmos
M7 net_0 bias_n_2 source_nmos source_nmos nmos
M8 outfirststage bias_n_2 source_nmos source_nmos nmos
M9 net_5 net_5 source_pmos source_pmos pmos
M10 net_1 net_6 net_5 net_5 pmos
M11 net_7 net_7 source_pmos source_pmos pmos
M12 out ibias net_7 net_7 pmos
M13 net_9 outfirststage source_nmos source_nmos nmos
M14 out bias_n_1 net_9 net_9 nmos
M15 bias_n_1 bias_n_1 source_nmos source_nmos nmos
M16 bias_n_2 bias_n_2 source_nmos source_nmos nmos
M17 net_6 net_6 bias_p_3m bias_p_3m pmos
M18 bias_p_3m net_5 source_pmos source_pmos pmos
M19 ibias ibias bias_p_4m bias_p_4m pmos
M20 bias_p_4m net_7 source_pmos source_pmos pmos
M21 bias_n_2 net_7 source_pmos source_pmos pmos
M22 bias_n_1 net_7 source_pmos source_pmos pmos
M23 net_6 bias_n_2 source_nmos source_nmos nmos
Cap_load_1 out source_nmos
Cap_compensation_1 outfirststage out
.end two_stage_single_output_op_amp2154
