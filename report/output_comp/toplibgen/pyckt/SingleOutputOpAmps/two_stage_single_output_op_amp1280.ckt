.suckt  two_stage_single_output_op_amp1280 ibias in1 in2 out source_nmos source_pmos
M1 net_0 in1 net_1 net_1 pmos
M2 net_2 in2 net_1 net_1 pmos
M3 net_3 net_4 net_0 net_0 pmos
M4 outfirststage net_4 net_2 net_2 pmos
M5 net_5 net_3 source_nmos source_nmos nmos
M6 net_3 bias_n_1 net_5 net_5 nmos
M7 net_7 net_3 source_nmos source_nmos nmos
M8 outfirststage bias_n_1 net_7 net_7 nmos
M9 net_8 bias_p_3b source_pmos source_pmos pmos
M10 net_1 ibias net_8 net_8 pmos
M11 out outfirststage source_pmos source_pmos pmos
M12 net_11 bias_n_2 source_nmos source_nmos nmos
M13 out bias_n_1 net_11 net_11 nmos
M14 bias_n_1 bias_n_1 source_nmos source_nmos nmos
M15 bias_n_2 bias_n_2 source_nmos source_nmos nmos
M16 net_4 net_4 net_1 net_1 pmos
M17 bias_p_3b bias_p_3b source_pmos source_pmos pmos
M18 ibias ibias bias_p_3b bias_p_3b pmos
M19 bias_n_2 bias_p_3b source_pmos source_pmos pmos
M20 bias_n_1 bias_p_3b source_pmos source_pmos pmos
M21 net_4 bias_n_2 source_nmos source_nmos nmos
Cap_load_1 out source_nmos
Cap_compensation_1 outfirststage out
.end two_stage_single_output_op_amp1280
