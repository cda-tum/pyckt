.suckt  two_stage_single_output_op_amp1266 ibias in1 in2 out source_nmos source_pmos
M1 net_0 in1 net_1 net_1 pmos
M2 net_2 in2 net_1 net_1 pmos
M3 net_3 net_4 net_0 net_0 pmos
M4 outfirststage net_4 net_2 net_2 pmos
M5 net_5 net_5 source_nmos source_nmos nmos
M6 net_3 net_3 net_5 net_5 nmos
M7 net_6 net_5 source_nmos source_nmos nmos
M8 outfirststage net_3 net_6 net_6 nmos
M9 net_7 net_7 source_pmos source_pmos pmos
M10 net_1 net_8 net_7 net_7 pmos
M11 net_9 net_9 source_pmos source_pmos pmos
M12 out ibias net_9 net_9 pmos
M13 net_11 outfirststage source_nmos source_nmos nmos
M14 out bias_n_1 net_11 net_11 nmos
M15 bias_n_1 bias_n_1 source_nmos source_nmos nmos
M16 net_4 net_4 net_1 net_1 pmos
M17 net_8 net_8 bias_p_2m bias_p_2m pmos
M18 bias_p_2m net_7 source_pmos source_pmos pmos
M19 ibias ibias bias_p_3m bias_p_3m pmos
M20 bias_p_3m net_9 source_pmos source_pmos pmos
M21 bias_n_4 bias_n_4 source_nmos source_nmos nmos
M22 bias_n_1 net_9 source_pmos source_pmos pmos
M23 net_4 bias_n_4 source_nmos source_nmos nmos
M24 net_8 bias_n_4 source_nmos source_nmos nmos
M25 bias_n_4 net_9 source_pmos source_pmos pmos
Cap_load_1 out source_nmos
Cap_compensation_1 outfirststage out
.end two_stage_single_output_op_amp1266
