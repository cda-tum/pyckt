.suckt  symmetrical_op_amp140 ibias in1 in2 out source_nmos source_pmos
M1 out2fs in1 net_0 net_0 pmos
M2 inoutputtc in2 net_0 net_0 pmos
M3 out1fs out1fs source_nmos source_nmos nmos
M4 out2fs out2fs out1fs out1fs nmos
M5 insourcetc insourcetc source_nmos source_nmos nmos
M6 inoutputtc inoutputtc insourcetc insourcetc nmos
M7 net_1 net_1 source_pmos source_pmos pmos
M8 net_0 ibias net_1 net_1 pmos
M9 insourcestagebias insourcestagebias source_pmos source_pmos pmos
M10 out inoutputstagebias insourcestagebias insourcestagebias pmos
M11 net_3 out1fs source_nmos source_nmos nmos
M12 out out2fs net_3 net_3 nmos
M13 net_4 insourcetc source_nmos source_nmos nmos
M14 inoutputstagebias inoutputtc net_4 net_4 nmos
M15 net_5 insourcestagebias source_pmos source_pmos pmos
M16 inoutputstagebias inoutputstagebias net_5 net_5 pmos
M17 ibias ibias bias_p_1m bias_p_1m pmos
M18 bias_p_1m net_1 source_pmos source_pmos pmos
Cap_load_1 out source_nmos
.end symmetrical_op_amp140
