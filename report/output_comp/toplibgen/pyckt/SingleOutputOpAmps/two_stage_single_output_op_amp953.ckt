.suckt  two_stage_single_output_op_amp953 ibias in1 in2 out source_nmos source_pmos
M1 net_0 in1 net_1 net_1 nmos
M2 net_2 in2 net_1 net_1 nmos
M3 net_0 bias_p_4b source_pmos source_pmos pmos
M4 net_4 bias_p_4t net_0 net_0 pmos
M5 net_2 bias_p_4b source_pmos source_pmos pmos
M6 outfirststage bias_p_4t net_2 net_2 pmos
M7 net_6 net_4 source_nmos source_nmos nmos
M8 net_4 bias_n_2 net_6 net_6 nmos
M9 net_8 net_4 source_nmos source_nmos nmos
M10 outfirststage bias_n_2 net_8 net_8 nmos
M11 net_9 net_9 source_nmos source_nmos nmos
M12 net_1 ibias net_9 net_9 nmos
M13 net_11 net_11 source_pmos source_pmos pmos
M14 out net_12 net_11 net_11 pmos
M15 out outfirststage source_nmos source_nmos nmos
M16 ibias ibias bias_n_1m bias_n_1m nmos
M17 bias_n_1m net_9 source_nmos source_nmos nmos
M18 bias_n_2 bias_n_2 source_nmos source_nmos nmos
M19 net_12 net_12 bias_p_3m bias_p_3m pmos
M20 bias_p_3m net_11 source_pmos source_pmos pmos
M21 bias_p_4b bias_p_4b source_pmos source_pmos pmos
M22 bias_p_4t bias_p_4t bias_p_4b bias_p_4b pmos
M23 bias_p_4t net_9 source_nmos source_nmos nmos
M24 bias_n_2 bias_p_4b source_pmos source_pmos pmos
M25 net_12 net_9 source_nmos source_nmos nmos
Cap_load_1 out source_nmos
Cap_compensation_1 outfirststage out
.end two_stage_single_output_op_amp953
