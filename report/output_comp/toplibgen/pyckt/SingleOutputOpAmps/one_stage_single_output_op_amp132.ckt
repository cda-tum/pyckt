.suckt  one_stage_single_output_op_amp132 ibias in1 in2 out source_nmos source_pmos
M1 net_0 in1 net_1 net_1 pmos
M2 out in2 net_1 net_1 pmos
M3 net_0 net_0 source_pmos source_pmos pmos
M4 net_2 net_0 source_pmos source_pmos pmos
M5 out bias_p_2 net_2 net_2 pmos
M6 net_4 bias_n_1b source_nmos source_nmos nmos
M7 net_0 ibias net_4 net_4 nmos
M8 net_7 bias_n_1b source_nmos source_nmos nmos
M9 out ibias net_7 net_7 nmos
M10 net_1 bias_p_3 source_pmos source_pmos pmos
M11 bias_n_1b bias_n_1b source_nmos source_nmos nmos
M12 ibias ibias bias_n_1b bias_n_1b nmos
M13 bias_p_2 bias_p_2 source_pmos source_pmos pmos
M14 bias_p_3 bias_p_3 source_pmos source_pmos pmos
M15 bias_p_3 bias_n_1b source_nmos source_nmos nmos
M16 bias_p_2 bias_n_1b source_nmos source_nmos nmos
Cap_load_1 out source_nmos
.end one_stage_single_output_op_amp132
