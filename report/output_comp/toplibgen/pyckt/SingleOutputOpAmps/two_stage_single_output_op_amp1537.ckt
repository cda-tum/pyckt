.suckt  two_stage_single_output_op_amp1537 ibias in1 in2 out source_nmos source_pmos
M1 net_0 in1 net_1 net_1 pmos
M2 outfirststage in2 net_1 net_1 pmos
M3 net_0 net_2 source_pmos source_pmos pmos
M4 net_2 net_2 source_pmos source_pmos pmos
M5 outfirststage net_0 net_2 net_2 pmos
M6 net_0 bias_n_1 source_nmos source_nmos nmos
M7 outfirststage bias_n_1 source_nmos source_nmos nmos
M8 net_1 ibias source_pmos source_pmos pmos
M9 out ibias source_pmos source_pmos pmos
M10 out outfirststage source_nmos source_nmos nmos
M11 bias_n_1 bias_n_1 source_nmos source_nmos nmos
M12 ibias ibias source_pmos source_pmos pmos
M13 bias_n_1 ibias source_pmos source_pmos pmos
Cap_load_1 out source_nmos
Cap_compensation_1 outfirststage out
.end two_stage_single_output_op_amp1537
