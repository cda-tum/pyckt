.suckt  one_stage_single_output_op_amp194 ibias in1 in2 out source_nmos source_pmos
M1 net_0 in1 net_1 net_1 nmos
M2 out in2 net_1 net_1 nmos
M3 net_0 net_0 source_nmos source_nmos nmos
M4 net_2 net_0 source_nmos source_nmos nmos
M5 out bias_n_2 net_2 net_2 nmos
M6 net_4 bias_p_3b source_pmos source_pmos pmos
M7 net_0 ibias net_4 net_4 pmos
M8 net_7 bias_p_3b source_pmos source_pmos pmos
M9 out ibias net_7 net_7 pmos
M10 net_8 net_8 source_nmos source_nmos nmos
M11 net_1 net_9 net_8 net_8 nmos
M12 net_9 net_9 bias_n_1m bias_n_1m nmos
M13 bias_n_1m net_8 source_nmos source_nmos nmos
M14 bias_n_2 bias_n_2 source_nmos source_nmos nmos
M15 bias_p_3b bias_p_3b source_pmos source_pmos pmos
M16 ibias ibias bias_p_3b bias_p_3b pmos
M17 net_9 bias_p_3b source_pmos source_pmos pmos
M18 bias_n_2 bias_p_3b source_pmos source_pmos pmos
Cap_load_1 out source_nmos
.end one_stage_single_output_op_amp194
