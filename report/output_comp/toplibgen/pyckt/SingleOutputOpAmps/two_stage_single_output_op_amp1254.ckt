.suckt  two_stage_single_output_op_amp1254 ibias in1 in2 out source_nmos source_pmos
M1 net_0 in1 net_1 net_1 pmos
M2 net_2 in2 net_1 net_1 pmos
M3 net_3 net_4 net_0 net_0 pmos
M4 outfirststage net_4 net_2 net_2 pmos
M5 net_5 net_5 source_nmos source_nmos nmos
M6 net_3 net_3 net_5 net_5 nmos
M7 net_6 net_5 source_nmos source_nmos nmos
M8 outfirststage net_3 net_6 net_6 nmos
M9 net_7 bias_p_3b source_pmos source_pmos pmos
M10 net_1 ibias net_7 net_7 pmos
M11 net_10 net_10 source_pmos source_pmos pmos
M12 out net_11 net_10 net_10 pmos
M13 net_12 outfirststage source_nmos source_nmos nmos
M14 out bias_n_1 net_12 net_12 nmos
M15 bias_n_1 bias_n_1 source_nmos source_nmos nmos
M16 net_4 net_4 net_1 net_1 pmos
M17 net_11 net_11 bias_p_2m bias_p_2m pmos
M18 bias_p_2m net_10 source_pmos source_pmos pmos
M19 bias_p_3b bias_p_3b source_pmos source_pmos pmos
M20 ibias ibias bias_p_3b bias_p_3b pmos
M21 bias_n_4 bias_n_4 source_nmos source_nmos nmos
M22 bias_n_1 bias_p_3b source_pmos source_pmos pmos
M23 net_4 bias_n_4 source_nmos source_nmos nmos
M24 net_11 bias_n_4 source_nmos source_nmos nmos
M25 bias_n_4 bias_p_3b source_pmos source_pmos pmos
Cap_load_1 out source_nmos
Cap_compensation_1 outfirststage out
.end two_stage_single_output_op_amp1254
