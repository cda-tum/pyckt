.suckt  two_stage_single_output_op_amp346 ibias in1 in2 out source_nmos source_pmos
M1 net_0 in1 net_1 net_1 nmos
M2 outfirststage in2 net_1 net_1 nmos
M3 net_0 net_0 source_pmos source_pmos pmos
M4 outfirststage net_0 source_pmos source_pmos pmos
M5 net_2 ibias source_nmos source_nmos nmos
M6 net_1 bias_n_1 net_2 net_2 nmos
M7 net_5 outfirststage source_pmos source_pmos pmos
M8 out bias_p_3 net_5 net_5 pmos
M9 out ibias source_nmos source_nmos nmos
M10 bias_n_1 bias_n_1 source_nmos source_nmos nmos
M11 ibias ibias source_nmos source_nmos nmos
M12 bias_p_3 bias_p_3 source_pmos source_pmos pmos
M13 bias_p_4 bias_p_4 source_pmos source_pmos pmos
M14 bias_n_1 bias_p_4 source_pmos source_pmos pmos
M15 bias_p_3 ibias source_nmos source_nmos nmos
M16 bias_p_4 ibias source_nmos source_nmos nmos
Cap_load_1 out source_nmos
Cap_compensation_1 outfirststage out
.end two_stage_single_output_op_amp346
