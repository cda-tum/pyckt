.suckt  two_stage_single_output_op_amp1248 ibias in1 in2 out source_nmos source_pmos
M1 net_0 in1 net_1 net_1 pmos
M2 net_2 in2 net_1 net_1 pmos
M3 net_3 net_4 net_0 net_0 pmos
M4 outfirststage net_4 net_2 net_2 pmos
M5 net_3 net_3 source_nmos source_nmos nmos
M6 net_5 net_3 source_nmos source_nmos nmos
M7 outfirststage bias_n_2 net_5 net_5 nmos
M8 net_7 net_7 source_pmos source_pmos pmos
M9 net_1 net_8 net_7 net_7 pmos
M10 net_9 outfirststage source_pmos source_pmos pmos
M11 out bias_p_4 net_9 net_9 pmos
M12 net_11 net_11 source_nmos source_nmos nmos
M13 out ibias net_11 net_11 nmos
M14 ibias ibias bias_n_1m bias_n_1m nmos
M15 bias_n_1m net_11 source_nmos source_nmos nmos
M16 bias_n_2 bias_n_2 source_nmos source_nmos nmos
M17 net_4 net_4 net_1 net_1 pmos
M18 net_8 net_8 bias_p_3m bias_p_3m pmos
M19 bias_p_3m net_7 source_pmos source_pmos pmos
M20 bias_p_4 bias_p_4 source_pmos source_pmos pmos
M21 bias_p_5 bias_p_5 source_pmos source_pmos pmos
M22 net_8 net_11 source_nmos source_nmos nmos
M23 bias_n_2 bias_p_5 source_pmos source_pmos pmos
M24 net_4 net_11 source_nmos source_nmos nmos
M25 bias_p_4 net_11 source_nmos source_nmos nmos
M26 bias_p_5 net_11 source_nmos source_nmos nmos
Cap_load_1 out source_nmos
Cap_compensation_1 outfirststage out
.end two_stage_single_output_op_amp1248
