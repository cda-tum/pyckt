.suckt  symmetrical_op_amp47 ibias in1 in2 out source_nmos source_pmos
M1 out1fs in1 net_0 net_0 pmos
M2 out2fs in2 net_0 net_0 pmos
M3 out1fs out1fs source_nmos source_nmos nmos
M4 out2fs out2fs source_nmos source_nmos nmos
M5 net_1 net_1 source_pmos source_pmos pmos
M6 net_0 ibias net_1 net_1 pmos
M7 net_3 insourcestagebias source_pmos source_pmos pmos
M8 out bias_p_2 net_3 net_3 pmos
M9 out out1fs source_nmos source_nmos nmos
M10 insourcestagebias out2fs source_nmos source_nmos nmos
M11 net_4 insourcestagebias source_pmos source_pmos pmos
M12 insourcestagebias bias_p_2 net_4 net_4 pmos
M13 ibias ibias bias_p_1m bias_p_1m pmos
M14 bias_p_1m net_1 source_pmos source_pmos pmos
M15 bias_p_2 bias_p_2 source_pmos source_pmos pmos
M16 bias_n_3 bias_n_3 source_nmos source_nmos nmos
M17 bias_p_2 bias_n_3 source_nmos source_nmos nmos
M18 bias_n_3 net_1 source_pmos source_pmos pmos
Cap_load_1 out source_nmos
.end symmetrical_op_amp47
