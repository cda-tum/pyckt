.suckt  two_stage_single_output_op_amp90 ibias in1 in2 out source_nmos source_pmos
M1 net_0 in1 net_1 net_1 nmos
M2 outfirststage in2 net_1 net_1 nmos
M3 net_0 net_0 source_pmos source_pmos pmos
M4 outfirststage net_0 source_pmos source_pmos pmos
M5 net_1 bias_n_2 source_nmos source_nmos nmos
M6 net_3 net_3 source_pmos source_pmos pmos
M7 out ibias net_3 net_3 pmos
M8 net_5 outfirststage source_nmos source_nmos nmos
M9 out bias_n_1 net_5 net_5 nmos
M10 bias_n_1 bias_n_1 source_nmos source_nmos nmos
M11 bias_n_2 bias_n_2 source_nmos source_nmos nmos
M12 ibias ibias bias_p_3m bias_p_3m pmos
M13 bias_p_3m net_3 source_pmos source_pmos pmos
M14 bias_n_2 net_3 source_pmos source_pmos pmos
M15 bias_n_1 net_3 source_pmos source_pmos pmos
Cap_load_1 out source_nmos
Cap_compensation_1 outfirststage out
.end two_stage_single_output_op_amp90
