.suckt  two_stage_single_output_op_amp99 ibias in1 in2 out source_nmos source_pmos
M1 net_0 in1 net_1 net_1 nmos
M2 outfirststage in2 net_1 net_1 nmos
M3 net_0 net_2 source_pmos source_pmos pmos
M4 net_2 net_2 source_pmos source_pmos pmos
M5 outfirststage net_0 net_2 net_2 pmos
M6 net_1 ibias source_nmos source_nmos nmos
M7 net_4 bias_p_2b source_pmos source_pmos pmos
M8 out bias_p_2t net_4 net_4 pmos
M9 out outfirststage source_nmos source_nmos nmos
M10 ibias ibias source_nmos source_nmos nmos
M11 bias_p_2b bias_p_2b source_pmos source_pmos pmos
M12 bias_p_2t bias_p_2t bias_p_2b bias_p_2b pmos
M13 bias_p_2t ibias source_nmos source_nmos nmos
Cap_load_1 out source_nmos
Cap_compensation_1 outfirststage out
.end two_stage_single_output_op_amp99
