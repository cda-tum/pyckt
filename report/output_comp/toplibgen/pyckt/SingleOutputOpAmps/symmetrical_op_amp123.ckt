.suckt  symmetrical_op_amp123 ibias in1 in2 out source_nmos source_pmos
M1 out2fs in1 net_0 net_0 nmos
M2 inoutputtc in2 net_0 net_0 nmos
M3 net_1 out2fs source_pmos source_pmos pmos
M4 out2fs out2fs net_1 net_1 pmos
M5 net_2 inoutputtc source_pmos source_pmos pmos
M6 inoutputtc inoutputtc net_2 net_2 pmos
M7 net_0 ibias source_nmos source_nmos nmos
M8 net_4 out2fs source_pmos source_pmos pmos
M9 out out2fs net_4 net_4 pmos
M10 net_5 insourcestagebias source_nmos source_nmos nmos
M11 out bias_n_1 net_5 net_5 nmos
M12 net_6 inoutputtc source_pmos source_pmos pmos
M13 insourcestagebias inoutputtc net_6 net_6 pmos
M14 net_7 insourcestagebias source_nmos source_nmos nmos
M15 insourcestagebias bias_n_1 net_7 net_7 nmos
M16 bias_n_1 bias_n_1 source_nmos source_nmos nmos
M17 ibias ibias source_nmos source_nmos nmos
M18 bias_p_3 bias_p_3 source_pmos source_pmos pmos
M19 bias_n_1 bias_p_3 source_pmos source_pmos pmos
M20 bias_p_3 ibias source_nmos source_nmos nmos
Cap_load_1 out source_nmos
.end symmetrical_op_amp123
