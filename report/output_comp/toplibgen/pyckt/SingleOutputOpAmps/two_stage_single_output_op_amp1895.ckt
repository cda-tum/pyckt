.suckt  two_stage_single_output_op_amp1895 ibias in1 in2 out source_nmos source_pmos
M1 net_0 in1 net_1 net_1 pmos
M2 outfirststage in2 net_1 net_1 pmos
M3 net_0 net_0 source_pmos source_pmos pmos
M4 outfirststage net_0 source_pmos source_pmos pmos
M5 net_2 bias_n_1b source_nmos source_nmos nmos
M6 net_0 ibias net_2 net_2 nmos
M7 net_5 bias_n_1b source_nmos source_nmos nmos
M8 outfirststage ibias net_5 net_5 nmos
M9 net_6 net_6 source_pmos source_pmos pmos
M10 net_1 net_7 net_6 net_6 pmos
M11 net_8 outfirststage source_pmos source_pmos pmos
M12 out bias_p_3 net_8 net_8 pmos
M13 net_10 bias_n_1b source_nmos source_nmos nmos
M14 out ibias net_10 net_10 nmos
M15 bias_n_1b bias_n_1b source_nmos source_nmos nmos
M16 ibias ibias bias_n_1b bias_n_1b nmos
M17 net_7 net_7 bias_p_2m bias_p_2m pmos
M18 bias_p_2m net_6 source_pmos source_pmos pmos
M19 bias_p_3 bias_p_3 source_pmos source_pmos pmos
M20 net_7 bias_n_1b source_nmos source_nmos nmos
M21 bias_p_3 bias_n_1b source_nmos source_nmos nmos
Cap_load_1 out source_nmos
Cap_compensation_1 outfirststage out
.end two_stage_single_output_op_amp1895
