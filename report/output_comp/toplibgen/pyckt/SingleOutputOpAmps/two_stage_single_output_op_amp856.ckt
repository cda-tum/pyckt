.suckt  two_stage_single_output_op_amp856 ibias in1 in2 out source_nmos source_pmos
M1 net_0 in1 net_1 net_1 nmos
M2 net_2 in2 net_1 net_1 nmos
M3 net_0 bias_p_3b source_pmos source_pmos pmos
M4 net_4 ibias net_0 net_0 pmos
M5 net_2 bias_p_3b source_pmos source_pmos pmos
M6 outfirststage ibias net_2 net_2 pmos
M7 net_4 net_4 source_nmos source_nmos nmos
M8 outfirststage net_4 source_nmos source_nmos nmos
M9 net_6 net_6 source_nmos source_nmos nmos
M10 net_1 net_7 net_6 net_6 nmos
M11 net_8 bias_p_3b source_pmos source_pmos pmos
M12 out ibias net_8 net_8 pmos
M13 net_11 outfirststage source_nmos source_nmos nmos
M14 out bias_n_2 net_11 net_11 nmos
M15 net_7 net_7 bias_n_1m bias_n_1m nmos
M16 bias_n_1m net_6 source_nmos source_nmos nmos
M17 bias_n_2 bias_n_2 source_nmos source_nmos nmos
M18 bias_p_3b bias_p_3b source_pmos source_pmos pmos
M19 ibias ibias bias_p_3b bias_p_3b pmos
M20 net_7 bias_p_3b source_pmos source_pmos pmos
M21 bias_n_2 bias_p_3b source_pmos source_pmos pmos
Cap_load_1 out source_nmos
Cap_compensation_1 outfirststage out
.end two_stage_single_output_op_amp856
