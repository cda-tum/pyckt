.suckt  one_stage_single_output_op_amp18 ibias in1 in2 out source_nmos source_pmos
M1 net_0 in1 net_1 net_1 pmos
M2 out in2 net_1 net_1 pmos
M3 net_0 net_2 source_nmos source_nmos nmos
M4 net_2 net_2 source_nmos source_nmos nmos
M5 out net_0 net_2 net_2 nmos
M6 net_3 net_3 source_pmos source_pmos pmos
M7 net_1 ibias net_3 net_3 pmos
M8 ibias ibias bias_p_1m bias_p_1m pmos
M9 bias_p_1m net_3 source_pmos source_pmos pmos
Cap_load_1 out source_nmos
.end one_stage_single_output_op_amp18
