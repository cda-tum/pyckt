.suckt  two_stage_single_output_op_amp330 ibias in1 in2 out source_nmos source_pmos
M1 net_0 in1 net_1 net_1 pmos
M2 outfirststage in2 net_1 net_1 pmos
M3 net_2 net_0 source_nmos source_nmos nmos
M4 net_0 net_0 net_2 net_2 nmos
M5 net_3 net_0 source_nmos source_nmos nmos
M6 outfirststage net_0 net_3 net_3 nmos
M7 net_4 net_4 source_pmos source_pmos pmos
M8 net_1 net_5 net_4 net_4 pmos
M9 net_6 net_6 source_pmos source_pmos pmos
M10 out ibias net_6 net_6 pmos
M11 net_8 outfirststage source_nmos source_nmos nmos
M12 out bias_n_1 net_8 net_8 nmos
M13 bias_n_1 bias_n_1 source_nmos source_nmos nmos
M14 net_5 net_5 bias_p_2m bias_p_2m pmos
M15 bias_p_2m net_4 source_pmos source_pmos pmos
M16 ibias ibias bias_p_3m bias_p_3m pmos
M17 bias_p_3m net_6 source_pmos source_pmos pmos
M18 bias_n_4 bias_n_4 source_nmos source_nmos nmos
M19 bias_n_1 net_6 source_pmos source_pmos pmos
M20 net_5 bias_n_4 source_nmos source_nmos nmos
M21 bias_n_4 net_6 source_pmos source_pmos pmos
Cap_load_1 out source_nmos
Cap_compensation_1 outfirststage out
.end two_stage_single_output_op_amp330
