.suckt  symmetrical_op_amp134 ibias in1 in2 out source_nmos source_pmos
M1 out2fs in1 net_0 net_0 pmos
M2 inoutputtc in2 net_0 net_0 pmos
M3 out1fs out1fs source_nmos source_nmos nmos
M4 out2fs out2fs out1fs out1fs nmos
M5 insourcetc insourcetc source_nmos source_nmos nmos
M6 inoutputtc inoutputtc insourcetc insourcetc nmos
M7 net_1 net_1 source_pmos source_pmos pmos
M8 net_0 ibias net_1 net_1 pmos
M9 out instagebias source_pmos source_pmos pmos
M10 net_3 out1fs source_nmos source_nmos nmos
M11 out out2fs net_3 net_3 nmos
M12 net_4 insourcetc source_nmos source_nmos nmos
M13 instagebias inoutputtc net_4 net_4 nmos
M14 instagebias instagebias source_pmos source_pmos pmos
M15 ibias ibias bias_p_1m bias_p_1m pmos
M16 bias_p_1m net_1 source_pmos source_pmos pmos
Cap_load_1 out source_nmos
.end symmetrical_op_amp134
