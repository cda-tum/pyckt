.suckt  symmetrical_op_amp179 ibias in1 in2 out source_nmos source_pmos
M1 out2fs in1 net_0 net_0 nmos
M2 inoutputtc in2 net_0 net_0 nmos
M3 out1fs out1fs source_pmos source_pmos pmos
M4 out2fs out2fs out1fs out1fs pmos
M5 insourcetc insourcetc source_pmos source_pmos pmos
M6 inoutputtc inoutputtc insourcetc insourcetc pmos
M7 net_1 net_1 source_nmos source_nmos nmos
M8 net_0 ibias net_1 net_1 nmos
M9 net_3 out1fs source_pmos source_pmos pmos
M10 out out2fs net_3 net_3 pmos
M11 net_4 insourcestagebias source_nmos source_nmos nmos
M12 out bias_n_2 net_4 net_4 nmos
M13 net_5 insourcetc source_pmos source_pmos pmos
M14 insourcestagebias inoutputtc net_5 net_5 pmos
M15 net_6 insourcestagebias source_nmos source_nmos nmos
M16 insourcestagebias bias_n_2 net_6 net_6 nmos
M17 ibias ibias bias_n_1m bias_n_1m nmos
M18 bias_n_1m net_1 source_nmos source_nmos nmos
M19 bias_n_2 bias_n_2 source_nmos source_nmos nmos
M20 bias_p_3 bias_p_3 source_pmos source_pmos pmos
M21 bias_n_2 bias_p_3 source_pmos source_pmos pmos
M22 bias_p_3 net_1 source_nmos source_nmos nmos
Cap_load_1 out source_nmos
.end symmetrical_op_amp179
