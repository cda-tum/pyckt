.suckt  symmetrical_op_amp74 ibias in1 in2 out source_nmos source_pmos
M1 out1fs in1 net_0 net_0 nmos
M2 out2fs in2 net_0 net_0 nmos
M3 out1fs out1fs source_pmos source_pmos pmos
M4 out2fs out2fs source_pmos source_pmos pmos
M5 net_1 net_1 source_nmos source_nmos nmos
M6 net_0 ibias net_1 net_1 nmos
M7 out out1fs source_pmos source_pmos pmos
M8 net_3 insourcestagebias source_nmos source_nmos nmos
M9 out bias_n_2 net_3 net_3 nmos
M10 insourcestagebias out2fs source_pmos source_pmos pmos
M11 net_4 insourcestagebias source_nmos source_nmos nmos
M12 insourcestagebias bias_n_2 net_4 net_4 nmos
M13 ibias ibias bias_n_1m bias_n_1m nmos
M14 bias_n_1m net_1 source_nmos source_nmos nmos
M15 bias_n_2 bias_n_2 source_nmos source_nmos nmos
M16 bias_p_3 bias_p_3 source_pmos source_pmos pmos
M17 bias_n_2 bias_p_3 source_pmos source_pmos pmos
M18 bias_p_3 net_1 source_nmos source_nmos nmos
Cap_load_1 out source_nmos
.end symmetrical_op_amp74
