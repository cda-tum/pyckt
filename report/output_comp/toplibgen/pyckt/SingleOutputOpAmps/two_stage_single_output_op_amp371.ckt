.suckt  two_stage_single_output_op_amp371 ibias in1 in2 out source_nmos source_pmos
M1 net_0 in1 net_1 net_1 nmos
M2 outfirststage in2 net_1 net_1 nmos
M3 net_0 net_2 source_pmos source_pmos pmos
M4 net_2 net_2 source_pmos source_pmos pmos
M5 outfirststage net_0 net_2 net_2 pmos
M6 net_3 bias_n_1b source_nmos source_nmos nmos
M7 net_1 ibias net_3 net_3 nmos
M8 net_6 outfirststage source_pmos source_pmos pmos
M9 out bias_p_2 net_6 net_6 pmos
M10 net_8 bias_n_1b source_nmos source_nmos nmos
M11 out ibias net_8 net_8 nmos
M12 bias_n_1b bias_n_1b source_nmos source_nmos nmos
M13 ibias ibias bias_n_1b bias_n_1b nmos
M14 bias_p_2 bias_p_2 source_pmos source_pmos pmos
M15 bias_p_2 bias_n_1b source_nmos source_nmos nmos
Cap_load_1 out source_nmos
Cap_compensation_1 outfirststage out
.end two_stage_single_output_op_amp371
