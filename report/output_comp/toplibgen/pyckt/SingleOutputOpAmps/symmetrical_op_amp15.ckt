.suckt  symmetrical_op_amp15 ibias in1 in2 out source_nmos source_pmos
M1 out1fs in1 net_0 net_0 nmos
M2 out2fs in2 net_0 net_0 nmos
M3 out1fs out1fs source_pmos source_pmos pmos
M4 out2fs out2fs source_pmos source_pmos pmos
M5 net_0 ibias source_nmos source_nmos nmos
M6 out out1fs source_pmos source_pmos pmos
M7 out instagebias source_nmos source_nmos nmos
M8 instagebias out2fs source_pmos source_pmos pmos
M9 instagebias instagebias source_nmos source_nmos nmos
M10 ibias ibias source_nmos source_nmos nmos
Cap_load_1 out source_nmos
.end symmetrical_op_amp15
