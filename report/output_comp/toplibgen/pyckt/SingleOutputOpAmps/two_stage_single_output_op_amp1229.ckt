.suckt  two_stage_single_output_op_amp1229 ibias in1 in2 out source_nmos source_pmos
M1 net_0 in1 net_1 net_1 pmos
M2 net_2 in2 net_1 net_1 pmos
M3 net_3 net_4 net_0 net_0 pmos
M4 outfirststage net_4 net_2 net_2 pmos
M5 net_3 net_3 source_nmos source_nmos nmos
M6 net_5 net_3 source_nmos source_nmos nmos
M7 outfirststage bias_n_1 net_5 net_5 nmos
M8 net_7 bias_p_3b source_pmos source_pmos pmos
M9 net_1 ibias net_7 net_7 pmos
M10 net_10 net_10 source_pmos source_pmos pmos
M11 out net_11 net_10 net_10 pmos
M12 out outfirststage source_nmos source_nmos nmos
M13 bias_n_1 bias_n_1 source_nmos source_nmos nmos
M14 net_4 net_4 net_1 net_1 pmos
M15 net_11 net_11 bias_p_2m bias_p_2m pmos
M16 bias_p_2m net_10 source_pmos source_pmos pmos
M17 bias_p_3b bias_p_3b source_pmos source_pmos pmos
M18 ibias ibias bias_p_3b bias_p_3b pmos
M19 bias_n_4 bias_n_4 source_nmos source_nmos nmos
M20 bias_n_1 bias_p_3b source_pmos source_pmos pmos
M21 net_4 bias_n_4 source_nmos source_nmos nmos
M22 net_11 bias_n_4 source_nmos source_nmos nmos
M23 bias_n_4 bias_p_3b source_pmos source_pmos pmos
Cap_load_1 out source_nmos
Cap_compensation_1 outfirststage out
.end two_stage_single_output_op_amp1229
