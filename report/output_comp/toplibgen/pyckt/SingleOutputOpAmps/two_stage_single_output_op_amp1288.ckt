.suckt  two_stage_single_output_op_amp1288 ibias in1 in2 out source_nmos source_pmos
M1 net_0 in1 net_1 net_1 pmos
M2 net_2 in2 net_1 net_1 pmos
M3 net_3 net_4 net_0 net_0 pmos
M4 outfirststage net_4 net_2 net_2 pmos
M5 net_5 net_3 source_nmos source_nmos nmos
M6 net_3 bias_n_1 net_5 net_5 nmos
M7 net_7 net_3 source_nmos source_nmos nmos
M8 outfirststage bias_n_1 net_7 net_7 nmos
M9 net_8 net_8 source_pmos source_pmos pmos
M10 net_1 net_9 net_8 net_8 pmos
M11 net_10 bias_p_3b source_pmos source_pmos pmos
M12 out ibias net_10 net_10 pmos
M13 net_13 outfirststage source_nmos source_nmos nmos
M14 out bias_n_1 net_13 net_13 nmos
M15 bias_n_1 bias_n_1 source_nmos source_nmos nmos
M16 net_4 net_4 net_1 net_1 pmos
M17 net_9 net_9 bias_p_2m bias_p_2m pmos
M18 bias_p_2m net_8 source_pmos source_pmos pmos
M19 bias_p_3b bias_p_3b source_pmos source_pmos pmos
M20 ibias ibias bias_p_3b bias_p_3b pmos
M21 bias_n_4 bias_n_4 source_nmos source_nmos nmos
M22 bias_n_1 bias_p_3b source_pmos source_pmos pmos
M23 net_4 bias_n_4 source_nmos source_nmos nmos
M24 net_9 bias_n_4 source_nmos source_nmos nmos
M25 bias_n_4 bias_p_3b source_pmos source_pmos pmos
Cap_load_1 out source_nmos
Cap_compensation_1 outfirststage out
.end two_stage_single_output_op_amp1288
