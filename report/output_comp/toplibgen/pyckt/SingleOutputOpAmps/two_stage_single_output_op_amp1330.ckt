.suckt  two_stage_single_output_op_amp1330 ibias in1 in2 out source_nmos source_pmos
M1 net_0 in1 net_1 net_1 pmos
M2 net_2 in2 net_1 net_1 pmos
M3 net_3 net_4 net_0 net_0 pmos
M4 outfirststage net_4 net_2 net_2 pmos
M5 net_5 net_3 source_nmos source_nmos nmos
M6 net_3 net_3 net_5 net_5 nmos
M7 net_6 net_3 source_nmos source_nmos nmos
M8 outfirststage net_3 net_6 net_6 nmos
M9 net_7 bias_p_3 source_pmos source_pmos pmos
M10 net_1 bias_p_2 net_7 net_7 pmos
M11 net_10 outfirststage source_pmos source_pmos pmos
M12 out bias_p_2 net_10 net_10 pmos
M13 out ibias source_nmos source_nmos nmos
M14 ibias ibias source_nmos source_nmos nmos
M15 net_4 net_4 net_1 net_1 pmos
M16 bias_p_2 bias_p_2 source_pmos source_pmos pmos
M17 bias_p_3 bias_p_3 source_pmos source_pmos pmos
M18 bias_p_3 ibias source_nmos source_nmos nmos
M19 net_4 ibias source_nmos source_nmos nmos
M20 bias_p_2 ibias source_nmos source_nmos nmos
Cap_load_1 out source_nmos
Cap_compensation_1 outfirststage out
.end two_stage_single_output_op_amp1330
