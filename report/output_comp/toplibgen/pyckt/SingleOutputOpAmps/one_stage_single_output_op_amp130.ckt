.suckt  one_stage_single_output_op_amp130 ibias in1 in2 out source_nmos source_pmos
M1 net_0 in1 net_1 net_1 pmos
M2 out in2 net_1 net_1 pmos
M3 net_0 net_2 source_pmos source_pmos pmos
M4 net_2 net_2 source_pmos source_pmos pmos
M5 out net_0 net_2 net_2 pmos
M6 net_3 bias_n_1b source_nmos source_nmos nmos
M7 net_0 bias_n_1t net_3 net_3 nmos
M8 net_6 bias_n_1b source_nmos source_nmos nmos
M9 out bias_n_1t net_6 net_6 nmos
M10 net_1 ibias source_pmos source_pmos pmos
M11 bias_n_1b bias_n_1b source_nmos source_nmos nmos
M12 bias_n_1t bias_n_1t bias_n_1b bias_n_1b nmos
M13 ibias ibias source_pmos source_pmos pmos
M14 bias_n_1t ibias source_pmos source_pmos pmos
Cap_load_1 out source_nmos
.end one_stage_single_output_op_amp130
