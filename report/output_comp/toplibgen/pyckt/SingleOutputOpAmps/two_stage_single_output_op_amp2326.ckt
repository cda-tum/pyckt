.suckt  two_stage_single_output_op_amp2326 ibias in1 in2 out source_nmos source_pmos
M1 net_0 in1 net_1 net_1 nmos
M2 outfirststage in2 net_1 net_1 nmos
M3 net_0 net_0 source_nmos source_nmos nmos
M4 net_2 net_0 source_nmos source_nmos nmos
M5 outfirststage bias_n_2 net_2 net_2 nmos
M6 net_4 ibias source_pmos source_pmos pmos
M7 net_0 bias_p_4 net_4 net_4 pmos
M8 net_7 ibias source_pmos source_pmos pmos
M9 outfirststage bias_p_4 net_7 net_7 pmos
M10 net_8 net_8 source_nmos source_nmos nmos
M11 net_1 net_9 net_8 net_8 nmos
M12 net_10 outfirststage source_pmos source_pmos pmos
M13 out bias_p_4 net_10 net_10 pmos
M14 out bias_n_3 source_nmos source_nmos nmos
M15 net_9 net_9 bias_n_1m bias_n_1m nmos
M16 bias_n_1m net_8 source_nmos source_nmos nmos
M17 bias_n_2 bias_n_2 source_nmos source_nmos nmos
M18 bias_n_3 bias_n_3 source_nmos source_nmos nmos
M19 bias_p_4 bias_p_4 source_pmos source_pmos pmos
M20 ibias ibias source_pmos source_pmos pmos
M21 bias_n_3 ibias source_pmos source_pmos pmos
M22 bias_n_2 ibias source_pmos source_pmos pmos
M23 bias_p_4 bias_n_3 source_nmos source_nmos nmos
M24 net_9 ibias source_pmos source_pmos pmos
Cap_load_1 out source_nmos
Cap_compensation_1 outfirststage out
.end two_stage_single_output_op_amp2326
