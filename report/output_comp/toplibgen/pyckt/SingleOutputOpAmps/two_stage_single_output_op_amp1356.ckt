.suckt  two_stage_single_output_op_amp1356 ibias in1 in2 out source_nmos source_pmos
M1 net_0 in1 net_1 net_1 nmos
M2 net_2 in2 net_1 net_1 nmos
M3 net_3 net_4 net_0 net_0 nmos
M4 outfirststage net_4 net_2 net_2 nmos
M5 net_3 net_3 source_pmos source_pmos pmos
M6 outfirststage net_3 source_pmos source_pmos pmos
M7 net_5 bias_n_2b source_nmos source_nmos nmos
M8 net_1 ibias net_5 net_5 nmos
M9 net_8 outfirststage source_pmos source_pmos pmos
M10 out bias_p_3 net_8 net_8 pmos
M11 net_10 net_10 source_nmos source_nmos nmos
M12 out net_11 net_10 net_10 nmos
M13 net_4 net_4 net_1 net_1 nmos
M14 net_11 net_11 bias_n_1m bias_n_1m nmos
M15 bias_n_1m net_10 source_nmos source_nmos nmos
M16 bias_n_2b bias_n_2b source_nmos source_nmos nmos
M17 ibias ibias bias_n_2b bias_n_2b nmos
M18 bias_p_3 bias_p_3 source_pmos source_pmos pmos
M19 bias_p_4 bias_p_4 source_pmos source_pmos pmos
M20 net_4 bias_p_4 source_pmos source_pmos pmos
M21 bias_p_3 bias_n_2b source_nmos source_nmos nmos
M22 net_11 bias_p_4 source_pmos source_pmos pmos
M23 bias_p_4 bias_n_2b source_nmos source_nmos nmos
Cap_load_1 out source_nmos
Cap_compensation_1 outfirststage out
.end two_stage_single_output_op_amp1356
