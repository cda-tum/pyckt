.suckt  two_stage_single_output_op_amp356 ibias in1 in2 out source_nmos source_pmos
M1 net_0 in1 net_1 net_1 nmos
M2 outfirststage in2 net_1 net_1 nmos
M3 net_0 net_0 source_pmos source_pmos pmos
M4 outfirststage net_0 source_pmos source_pmos pmos
M5 net_2 net_2 source_nmos source_nmos nmos
M6 net_1 net_3 net_2 net_2 nmos
M7 out outfirststage source_pmos source_pmos pmos
M8 net_4 bias_n_2b source_nmos source_nmos nmos
M9 out ibias net_4 net_4 nmos
M10 net_3 net_3 bias_n_1m bias_n_1m nmos
M11 bias_n_1m net_2 source_nmos source_nmos nmos
M12 bias_n_2b bias_n_2b source_nmos source_nmos nmos
M13 ibias ibias bias_n_2b bias_n_2b nmos
M14 bias_p_3 bias_p_3 source_pmos source_pmos pmos
M15 net_3 bias_p_3 source_pmos source_pmos pmos
M16 bias_p_3 bias_n_2b source_nmos source_nmos nmos
Cap_load_1 out source_nmos
Cap_compensation_1 outfirststage out
.end two_stage_single_output_op_amp356
