.suckt  one_stage_single_output_op_amp8 ibias in1 in2 out source_nmos source_pmos
M1 net_0 in1 net_1 net_1 nmos
M2 out in2 net_1 net_1 nmos
M3 net_0 net_0 source_pmos source_pmos pmos
M4 out net_0 source_pmos source_pmos pmos
M5 net_1 ibias source_nmos source_nmos nmos
M6 ibias ibias source_nmos source_nmos nmos
Cap_load_1 out source_nmos
.end one_stage_single_output_op_amp8
