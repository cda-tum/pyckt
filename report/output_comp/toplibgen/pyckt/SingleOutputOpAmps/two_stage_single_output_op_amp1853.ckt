.suckt  two_stage_single_output_op_amp1853 ibias in1 in2 out source_nmos source_pmos
M1 net_0 in1 net_1 net_1 pmos
M2 outfirststage in2 net_1 net_1 pmos
M3 net_0 net_0 source_pmos source_pmos pmos
M4 outfirststage net_0 source_pmos source_pmos pmos
M5 net_0 ibias source_nmos source_nmos nmos
M6 outfirststage ibias source_nmos source_nmos nmos
M7 net_3 bias_p_3b source_pmos source_pmos pmos
M8 net_1 bias_p_3t net_3 net_3 pmos
M9 net_6 net_6 source_pmos source_pmos pmos
M10 out net_7 net_6 net_6 pmos
M11 out outfirststage source_nmos source_nmos nmos
M12 ibias ibias source_nmos source_nmos nmos
M13 net_7 net_7 bias_p_2m bias_p_2m pmos
M14 bias_p_2m net_6 source_pmos source_pmos pmos
M15 bias_p_3b bias_p_3b source_pmos source_pmos pmos
M16 bias_p_3t bias_p_3t bias_p_3b bias_p_3b pmos
M17 bias_p_3t ibias source_nmos source_nmos nmos
M18 net_7 ibias source_nmos source_nmos nmos
Cap_load_1 out source_nmos
Cap_compensation_1 outfirststage out
.end two_stage_single_output_op_amp1853
