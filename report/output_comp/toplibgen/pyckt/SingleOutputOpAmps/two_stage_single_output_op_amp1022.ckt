.suckt  two_stage_single_output_op_amp1022 ibias in1 in2 out source_nmos source_pmos
M1 net_0 in1 net_1 net_1 pmos
M2 net_2 in2 net_1 net_1 pmos
M3 net_3 net_4 net_0 net_0 pmos
M4 outfirststage net_4 net_2 net_2 pmos
M5 net_3 net_5 source_nmos source_nmos nmos
M6 net_5 net_5 source_nmos source_nmos nmos
M7 outfirststage net_3 net_5 net_5 nmos
M8 net_1 ibias source_pmos source_pmos pmos
M9 out ibias source_pmos source_pmos pmos
M10 net_8 outfirststage source_nmos source_nmos nmos
M11 out bias_n_1 net_8 net_8 nmos
M12 bias_n_1 bias_n_1 source_nmos source_nmos nmos
M13 net_4 net_4 net_1 net_1 pmos
M14 ibias ibias source_pmos source_pmos pmos
M15 bias_n_3 bias_n_3 source_nmos source_nmos nmos
M16 bias_n_1 ibias source_pmos source_pmos pmos
M17 net_4 bias_n_3 source_nmos source_nmos nmos
M18 bias_n_3 ibias source_pmos source_pmos pmos
Cap_load_1 out source_nmos
Cap_compensation_1 outfirststage out
.end two_stage_single_output_op_amp1022
