.suckt  two_stage_single_output_op_amp88 ibias in1 in2 out source_nmos source_pmos
M1 net_0 in1 net_1 net_1 nmos
M2 outfirststage in2 net_1 net_1 nmos
M3 net_0 net_0 source_pmos source_pmos pmos
M4 outfirststage net_0 source_pmos source_pmos pmos
M5 net_1 bias_n_2 source_nmos source_nmos nmos
M6 net_3 bias_p_3b source_pmos source_pmos pmos
M7 out ibias net_3 net_3 pmos
M8 net_6 outfirststage source_nmos source_nmos nmos
M9 out bias_n_1 net_6 net_6 nmos
M10 bias_n_1 bias_n_1 source_nmos source_nmos nmos
M11 bias_n_2 bias_n_2 source_nmos source_nmos nmos
M12 bias_p_3b bias_p_3b source_pmos source_pmos pmos
M13 ibias ibias bias_p_3b bias_p_3b pmos
M14 bias_n_2 bias_p_3b source_pmos source_pmos pmos
M15 bias_n_1 bias_p_3b source_pmos source_pmos pmos
Cap_load_1 out source_nmos
Cap_compensation_1 outfirststage out
.end two_stage_single_output_op_amp88
