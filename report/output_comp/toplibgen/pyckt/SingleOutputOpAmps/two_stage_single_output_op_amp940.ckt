.suckt  two_stage_single_output_op_amp940 ibias in1 in2 out source_nmos source_pmos
M1 net_0 in1 net_1 net_1 nmos
M2 net_2 in2 net_1 net_1 nmos
M3 net_0 bias_p_3b source_pmos source_pmos pmos
M4 net_4 ibias net_0 net_0 pmos
M5 net_2 bias_p_3b source_pmos source_pmos pmos
M6 outfirststage ibias net_2 net_2 pmos
M7 net_6 net_4 source_nmos source_nmos nmos
M8 net_4 bias_n_1 net_6 net_6 nmos
M9 net_8 net_4 source_nmos source_nmos nmos
M10 outfirststage bias_n_1 net_8 net_8 nmos
M11 net_9 bias_n_2 source_nmos source_nmos nmos
M12 net_1 bias_n_1 net_9 net_9 nmos
M13 net_12 bias_p_3b source_pmos source_pmos pmos
M14 out ibias net_12 net_12 pmos
M15 net_15 outfirststage source_nmos source_nmos nmos
M16 out bias_n_1 net_15 net_15 nmos
M17 bias_n_1 bias_n_1 source_nmos source_nmos nmos
M18 bias_n_2 bias_n_2 source_nmos source_nmos nmos
M19 bias_p_3b bias_p_3b source_pmos source_pmos pmos
M20 ibias ibias bias_p_3b bias_p_3b pmos
M21 bias_n_2 bias_p_3b source_pmos source_pmos pmos
M22 bias_n_1 bias_p_3b source_pmos source_pmos pmos
Cap_load_1 out source_nmos
Cap_compensation_1 outfirststage out
.end two_stage_single_output_op_amp940
