.suckt  two_stage_single_output_op_amp1283 ibias in1 in2 out source_nmos source_pmos
M1 net_0 in1 net_1 net_1 pmos
M2 net_2 in2 net_1 net_1 pmos
M3 net_3 net_4 net_0 net_0 pmos
M4 outfirststage net_4 net_2 net_2 pmos
M5 net_5 net_3 source_nmos source_nmos nmos
M6 net_3 bias_n_1 net_5 net_5 nmos
M7 net_7 net_3 source_nmos source_nmos nmos
M8 outfirststage bias_n_1 net_7 net_7 nmos
M9 net_8 bias_p_4 source_pmos source_pmos pmos
M10 net_1 bias_p_3 net_8 net_8 pmos
M11 net_11 outfirststage source_pmos source_pmos pmos
M12 out bias_p_3 net_11 net_11 pmos
M13 net_13 ibias source_nmos source_nmos nmos
M14 out bias_n_1 net_13 net_13 nmos
M15 bias_n_1 bias_n_1 source_nmos source_nmos nmos
M16 ibias ibias source_nmos source_nmos nmos
M17 net_4 net_4 net_1 net_1 pmos
M18 bias_p_3 bias_p_3 source_pmos source_pmos pmos
M19 bias_p_4 bias_p_4 source_pmos source_pmos pmos
M20 bias_p_4 ibias source_nmos source_nmos nmos
M21 bias_n_1 bias_p_4 source_pmos source_pmos pmos
M22 net_4 ibias source_nmos source_nmos nmos
M23 bias_p_3 ibias source_nmos source_nmos nmos
Cap_load_1 out source_nmos
Cap_compensation_1 outfirststage out
.end two_stage_single_output_op_amp1283
