.suckt  symmetrical_op_amp127 ibias in1 in2 out source_nmos source_pmos
M1 out2fs in1 net_0 net_0 pmos
M2 inoutputtc in2 net_0 net_0 pmos
M3 out1fs out1fs source_nmos source_nmos nmos
M4 out2fs out2fs out1fs out1fs nmos
M5 insourcetc insourcetc source_nmos source_nmos nmos
M6 inoutputtc inoutputtc insourcetc insourcetc nmos
M7 net_1 bias_p_1b source_pmos source_pmos pmos
M8 net_0 ibias net_1 net_1 pmos
M9 out instagebias source_pmos source_pmos pmos
M10 net_4 out1fs source_nmos source_nmos nmos
M11 out out2fs net_4 net_4 nmos
M12 net_5 insourcetc source_nmos source_nmos nmos
M13 instagebias inoutputtc net_5 net_5 nmos
M14 instagebias instagebias source_pmos source_pmos pmos
M15 bias_p_1b bias_p_1b source_pmos source_pmos pmos
M16 ibias ibias bias_p_1b bias_p_1b pmos
Cap_load_1 out source_nmos
.end symmetrical_op_amp127
