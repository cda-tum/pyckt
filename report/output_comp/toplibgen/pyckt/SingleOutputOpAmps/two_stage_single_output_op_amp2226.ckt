.suckt  two_stage_single_output_op_amp2226 ibias in1 in2 out source_nmos source_pmos
M1 net_0 in1 net_1 net_1 nmos
M2 outfirststage in2 net_1 net_1 nmos
M3 net_0 net_0 source_nmos source_nmos nmos
M4 outfirststage net_0 source_nmos source_nmos nmos
M5 net_2 bias_p_4b source_pmos source_pmos pmos
M6 net_0 bias_p_4t net_2 net_2 pmos
M7 net_5 bias_p_4b source_pmos source_pmos pmos
M8 outfirststage bias_p_4t net_5 net_5 pmos
M9 net_6 net_6 source_nmos source_nmos nmos
M10 net_1 ibias net_6 net_6 nmos
M11 net_8 net_8 source_pmos source_pmos pmos
M12 out net_9 net_8 net_8 pmos
M13 net_10 outfirststage source_nmos source_nmos nmos
M14 out bias_n_2 net_10 net_10 nmos
M15 ibias ibias bias_n_1m bias_n_1m nmos
M16 bias_n_1m net_6 source_nmos source_nmos nmos
M17 bias_n_2 bias_n_2 source_nmos source_nmos nmos
M18 net_9 net_9 bias_p_3m bias_p_3m pmos
M19 bias_p_3m net_8 source_pmos source_pmos pmos
M20 bias_p_4b bias_p_4b source_pmos source_pmos pmos
M21 bias_p_4t bias_p_4t bias_p_4b bias_p_4b pmos
M22 bias_p_4t net_6 source_nmos source_nmos nmos
M23 bias_n_2 bias_p_4b source_pmos source_pmos pmos
M24 net_9 net_6 source_nmos source_nmos nmos
Cap_load_1 out source_nmos
Cap_compensation_1 outfirststage out
.end two_stage_single_output_op_amp2226
