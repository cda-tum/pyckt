.suckt  two_stage_single_output_op_amp1944 ibias in1 in2 out source_nmos source_pmos
M1 net_0 in1 net_1 net_1 pmos
M2 outfirststage in2 net_1 net_1 pmos
M3 net_0 net_2 source_pmos source_pmos pmos
M4 net_2 net_2 source_pmos source_pmos pmos
M5 outfirststage net_0 net_2 net_2 pmos
M6 net_3 bias_n_2b source_nmos source_nmos nmos
M7 net_0 bias_n_2t net_3 net_3 nmos
M8 net_6 bias_n_2b source_nmos source_nmos nmos
M9 outfirststage bias_n_2t net_6 net_6 nmos
M10 net_7 net_7 source_pmos source_pmos pmos
M11 net_1 ibias net_7 net_7 pmos
M12 net_9 outfirststage source_pmos source_pmos pmos
M13 out bias_p_4 net_9 net_9 pmos
M14 net_11 net_11 source_nmos source_nmos nmos
M15 out net_12 net_11 net_11 nmos
M16 net_12 net_12 bias_n_1m bias_n_1m nmos
M17 bias_n_1m net_11 source_nmos source_nmos nmos
M18 bias_n_2b bias_n_2b source_nmos source_nmos nmos
M19 bias_n_2t bias_n_2t bias_n_2b bias_n_2b nmos
M20 ibias ibias bias_p_3m bias_p_3m pmos
M21 bias_p_3m net_7 source_pmos source_pmos pmos
M22 bias_p_4 bias_p_4 source_pmos source_pmos pmos
M23 bias_n_2t net_7 source_pmos source_pmos pmos
M24 bias_p_4 bias_n_2b source_nmos source_nmos nmos
M25 net_12 net_7 source_pmos source_pmos pmos
Cap_load_1 out source_nmos
Cap_compensation_1 outfirststage out
.end two_stage_single_output_op_amp1944
