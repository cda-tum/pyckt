.suckt  two_stage_single_output_op_amp1349 ibias in1 in2 out source_nmos source_pmos
M1 net_0 in1 net_1 net_1 nmos
M2 net_2 in2 net_1 net_1 nmos
M3 net_3 net_4 net_0 net_0 nmos
M4 outfirststage net_4 net_2 net_2 nmos
M5 net_3 net_3 source_pmos source_pmos pmos
M6 outfirststage net_3 source_pmos source_pmos pmos
M7 net_5 bias_n_1b source_nmos source_nmos nmos
M8 net_1 bias_n_1t net_5 net_5 nmos
M9 net_8 net_8 source_pmos source_pmos pmos
M10 out ibias net_8 net_8 pmos
M11 out outfirststage source_nmos source_nmos nmos
M12 net_4 net_4 net_1 net_1 nmos
M13 bias_n_1b bias_n_1b source_nmos source_nmos nmos
M14 bias_n_1t bias_n_1t bias_n_1b bias_n_1b nmos
M15 ibias ibias bias_p_2m bias_p_2m pmos
M16 bias_p_2m net_8 source_pmos source_pmos pmos
M17 bias_n_1t net_8 source_pmos source_pmos pmos
M18 net_4 net_8 source_pmos source_pmos pmos
Cap_load_1 out source_nmos
Cap_compensation_1 outfirststage out
.end two_stage_single_output_op_amp1349
