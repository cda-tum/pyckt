.suckt  one_stage_single_output_op_amp173 ibias in1 in2 out source_nmos source_pmos
M1 net_0 in1 net_1 net_1 pmos
M2 out in2 net_1 net_1 pmos
M3 net_2 net_0 source_pmos source_pmos pmos
M4 net_0 bias_p_2 net_2 net_2 pmos
M5 net_4 net_0 source_pmos source_pmos pmos
M6 out bias_p_2 net_4 net_4 pmos
M7 net_5 bias_n_1b source_nmos source_nmos nmos
M8 net_0 ibias net_5 net_5 nmos
M9 net_8 bias_n_1b source_nmos source_nmos nmos
M10 out ibias net_8 net_8 nmos
M11 net_9 bias_p_3 source_pmos source_pmos pmos
M12 net_1 bias_p_2 net_9 net_9 pmos
M13 bias_n_1b bias_n_1b source_nmos source_nmos nmos
M14 ibias ibias bias_n_1b bias_n_1b nmos
M15 bias_p_2 bias_p_2 source_pmos source_pmos pmos
M16 bias_p_3 bias_p_3 source_pmos source_pmos pmos
M17 bias_p_3 bias_n_1b source_nmos source_nmos nmos
M18 bias_p_2 bias_n_1b source_nmos source_nmos nmos
Cap_load_1 out source_nmos
.end one_stage_single_output_op_amp173
