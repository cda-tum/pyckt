.suckt  two_stage_single_output_op_amp1044 ibias in1 in2 out source_nmos source_pmos
M1 net_0 in1 net_1 net_1 pmos
M2 net_2 in2 net_1 net_1 pmos
M3 net_3 net_4 net_0 net_0 pmos
M4 outfirststage net_4 net_2 net_2 pmos
M5 net_3 net_3 source_nmos source_nmos nmos
M6 net_5 net_3 source_nmos source_nmos nmos
M7 outfirststage bias_n_2 net_5 net_5 nmos
M8 net_1 bias_p_4 source_pmos source_pmos pmos
M9 net_8 outfirststage source_pmos source_pmos pmos
M10 out bias_p_3 net_8 net_8 pmos
M11 net_10 net_10 source_nmos source_nmos nmos
M12 out ibias net_10 net_10 nmos
M13 ibias ibias bias_n_1m bias_n_1m nmos
M14 bias_n_1m net_10 source_nmos source_nmos nmos
M15 bias_n_2 bias_n_2 source_nmos source_nmos nmos
M16 net_4 net_4 net_1 net_1 pmos
M17 bias_p_3 bias_p_3 source_pmos source_pmos pmos
M18 bias_p_4 bias_p_4 source_pmos source_pmos pmos
M19 bias_p_4 net_10 source_nmos source_nmos nmos
M20 bias_n_2 bias_p_4 source_pmos source_pmos pmos
M21 net_4 net_10 source_nmos source_nmos nmos
M22 bias_p_3 net_10 source_nmos source_nmos nmos
Cap_load_1 out source_nmos
Cap_compensation_1 outfirststage out
.end two_stage_single_output_op_amp1044
