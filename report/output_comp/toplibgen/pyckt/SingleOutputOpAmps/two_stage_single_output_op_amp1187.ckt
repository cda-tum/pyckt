.suckt  two_stage_single_output_op_amp1187 ibias in1 in2 out source_nmos source_pmos
M1 net_0 in1 net_1 net_1 pmos
M2 net_2 in2 net_1 net_1 pmos
M3 net_3 net_4 net_0 net_0 pmos
M4 outfirststage net_4 net_2 net_2 pmos
M5 net_3 net_3 source_nmos source_nmos nmos
M6 outfirststage net_3 source_nmos source_nmos nmos
M7 net_5 bias_p_3 source_pmos source_pmos pmos
M8 net_1 bias_p_2 net_5 net_5 pmos
M9 net_8 outfirststage source_pmos source_pmos pmos
M10 out bias_p_2 net_8 net_8 pmos
M11 net_10 bias_n_1b source_nmos source_nmos nmos
M12 out ibias net_10 net_10 nmos
M13 bias_n_1b bias_n_1b source_nmos source_nmos nmos
M14 ibias ibias bias_n_1b bias_n_1b nmos
M15 net_4 net_4 net_1 net_1 pmos
M16 bias_p_2 bias_p_2 source_pmos source_pmos pmos
M17 bias_p_3 bias_p_3 source_pmos source_pmos pmos
M18 bias_p_3 bias_n_1b source_nmos source_nmos nmos
M19 net_4 bias_n_1b source_nmos source_nmos nmos
M20 bias_p_2 bias_n_1b source_nmos source_nmos nmos
Cap_load_1 out source_nmos
Cap_compensation_1 outfirststage out
.end two_stage_single_output_op_amp1187
