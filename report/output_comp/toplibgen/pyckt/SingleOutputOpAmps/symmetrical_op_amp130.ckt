.suckt  symmetrical_op_amp130 ibias in1 in2 out source_nmos source_pmos
M1 out2fs in1 net_0 net_0 pmos
M2 inoutputtc in2 net_0 net_0 pmos
M3 out1fs out1fs source_nmos source_nmos nmos
M4 out2fs out2fs out1fs out1fs nmos
M5 insourcetc insourcetc source_nmos source_nmos nmos
M6 inoutputtc inoutputtc insourcetc insourcetc nmos
M7 net_1 ibias source_pmos source_pmos pmos
M8 net_0 bias_p_1 net_1 net_1 pmos
M9 net_4 insourcestagebias source_pmos source_pmos pmos
M10 out bias_p_1 net_4 net_4 pmos
M11 net_5 out1fs source_nmos source_nmos nmos
M12 out out2fs net_5 net_5 nmos
M13 net_6 insourcetc source_nmos source_nmos nmos
M14 insourcestagebias inoutputtc net_6 net_6 nmos
M15 net_7 insourcestagebias source_pmos source_pmos pmos
M16 insourcestagebias bias_p_1 net_7 net_7 pmos
M17 bias_p_1 bias_p_1 source_pmos source_pmos pmos
M18 ibias ibias source_pmos source_pmos pmos
M19 bias_n_3 bias_n_3 source_nmos source_nmos nmos
M20 bias_p_1 bias_n_3 source_nmos source_nmos nmos
M21 bias_n_3 ibias source_pmos source_pmos pmos
Cap_load_1 out source_nmos
.end symmetrical_op_amp130
