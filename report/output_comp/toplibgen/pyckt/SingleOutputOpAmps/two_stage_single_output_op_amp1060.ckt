.suckt  two_stage_single_output_op_amp1060 ibias in1 in2 out source_nmos source_pmos
M1 net_0 in1 net_1 net_1 pmos
M2 net_2 in2 net_1 net_1 pmos
M3 net_3 net_4 net_0 net_0 pmos
M4 outfirststage net_4 net_2 net_2 pmos
M5 net_5 net_3 source_nmos source_nmos nmos
M6 net_3 bias_n_1 net_5 net_5 nmos
M7 net_7 net_3 source_nmos source_nmos nmos
M8 outfirststage bias_n_1 net_7 net_7 nmos
M9 net_1 ibias source_pmos source_pmos pmos
M10 net_9 ibias source_pmos source_pmos pmos
M11 out bias_p_2 net_9 net_9 pmos
M12 net_12 outfirststage source_nmos source_nmos nmos
M13 out bias_n_1 net_12 net_12 nmos
M14 bias_n_1 bias_n_1 source_nmos source_nmos nmos
M15 net_4 net_4 net_1 net_1 pmos
M16 bias_p_2 bias_p_2 source_pmos source_pmos pmos
M17 ibias ibias source_pmos source_pmos pmos
M18 bias_n_4 bias_n_4 source_nmos source_nmos nmos
M19 bias_n_1 ibias source_pmos source_pmos pmos
M20 net_4 bias_n_4 source_nmos source_nmos nmos
M21 bias_p_2 bias_n_4 source_nmos source_nmos nmos
M22 bias_n_4 ibias source_pmos source_pmos pmos
Cap_load_1 out source_nmos
Cap_compensation_1 outfirststage out
.end two_stage_single_output_op_amp1060
