.suckt  two_stage_single_output_op_amp2205 ibias in1 in2 out source_nmos source_pmos
M1 net_0 in1 net_1 net_1 nmos
M2 outfirststage in2 net_1 net_1 nmos
M3 net_0 net_0 source_nmos source_nmos nmos
M4 outfirststage net_0 source_nmos source_nmos nmos
M5 net_0 ibias source_pmos source_pmos pmos
M6 outfirststage ibias source_pmos source_pmos pmos
M7 net_3 net_3 source_nmos source_nmos nmos
M8 net_1 net_4 net_3 net_3 nmos
M9 out outfirststage source_pmos source_pmos pmos
M10 net_5 net_5 source_nmos source_nmos nmos
M11 out net_6 net_5 net_5 nmos
M12 net_4 net_4 bias_n_1m bias_n_1m nmos
M13 bias_n_1m net_3 source_nmos source_nmos nmos
M14 net_6 net_6 bias_n_2m bias_n_2m nmos
M15 bias_n_2m net_5 source_nmos source_nmos nmos
M16 ibias ibias source_pmos source_pmos pmos
M17 net_6 ibias source_pmos source_pmos pmos
M18 net_4 ibias source_pmos source_pmos pmos
Cap_load_1 out source_nmos
Cap_compensation_1 outfirststage out
.end two_stage_single_output_op_amp2205
