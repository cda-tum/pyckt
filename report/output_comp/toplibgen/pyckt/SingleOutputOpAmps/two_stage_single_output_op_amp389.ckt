.suckt  two_stage_single_output_op_amp389 ibias in1 in2 out source_nmos source_pmos
M1 net_0 in1 net_1 net_1 nmos
M2 outfirststage in2 net_1 net_1 nmos
M3 net_0 net_0 source_pmos source_pmos pmos
M4 net_2 net_0 source_pmos source_pmos pmos
M5 outfirststage bias_p_3 net_2 net_2 pmos
M6 net_4 bias_n_1b source_nmos source_nmos nmos
M7 net_1 ibias net_4 net_4 nmos
M8 net_7 net_7 source_pmos source_pmos pmos
M9 out net_8 net_7 net_7 pmos
M10 out outfirststage source_nmos source_nmos nmos
M11 bias_n_1b bias_n_1b source_nmos source_nmos nmos
M12 ibias ibias bias_n_1b bias_n_1b nmos
M13 net_8 net_8 bias_p_2m bias_p_2m pmos
M14 bias_p_2m net_7 source_pmos source_pmos pmos
M15 bias_p_3 bias_p_3 source_pmos source_pmos pmos
M16 net_8 bias_n_1b source_nmos source_nmos nmos
M17 bias_p_3 bias_n_1b source_nmos source_nmos nmos
Cap_load_1 out source_nmos
Cap_compensation_1 outfirststage out
.end two_stage_single_output_op_amp389
