.suckt  two_stage_single_output_op_amp161 ibias in1 in2 out source_nmos source_pmos
M1 net_0 in1 net_1 net_1 nmos
M2 outfirststage in2 net_1 net_1 nmos
M3 net_2 net_0 source_pmos source_pmos pmos
M4 net_0 net_0 net_2 net_2 pmos
M5 net_3 net_0 source_pmos source_pmos pmos
M6 outfirststage net_0 net_3 net_3 pmos
M7 net_1 ibias source_nmos source_nmos nmos
M8 net_5 net_5 source_pmos source_pmos pmos
M9 out net_6 net_5 net_5 pmos
M10 out outfirststage source_nmos source_nmos nmos
M11 ibias ibias source_nmos source_nmos nmos
M12 net_6 net_6 bias_p_2m bias_p_2m pmos
M13 bias_p_2m net_5 source_pmos source_pmos pmos
M14 net_6 ibias source_nmos source_nmos nmos
Cap_load_1 out source_nmos
Cap_compensation_1 outfirststage out
.end two_stage_single_output_op_amp161
