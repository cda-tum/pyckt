.suckt  two_stage_single_output_op_amp1580 ibias in1 in2 out source_nmos source_pmos
M1 net_0 in1 net_1 net_1 pmos
M2 outfirststage in2 net_1 net_1 pmos
M3 net_0 net_0 source_pmos source_pmos pmos
M4 net_2 net_0 source_pmos source_pmos pmos
M5 outfirststage bias_p_2 net_2 net_2 pmos
M6 net_4 bias_n_1b source_nmos source_nmos nmos
M7 net_0 ibias net_4 net_4 nmos
M8 net_7 bias_n_1b source_nmos source_nmos nmos
M9 outfirststage ibias net_7 net_7 nmos
M10 net_1 bias_p_3 source_pmos source_pmos pmos
M11 out outfirststage source_pmos source_pmos pmos
M12 net_9 bias_n_1b source_nmos source_nmos nmos
M13 out ibias net_9 net_9 nmos
M14 bias_n_1b bias_n_1b source_nmos source_nmos nmos
M15 ibias ibias bias_n_1b bias_n_1b nmos
M16 bias_p_2 bias_p_2 source_pmos source_pmos pmos
M17 bias_p_3 bias_p_3 source_pmos source_pmos pmos
M18 bias_p_3 bias_n_1b source_nmos source_nmos nmos
M19 bias_p_2 bias_n_1b source_nmos source_nmos nmos
Cap_load_1 out source_nmos
Cap_compensation_1 outfirststage out
.end two_stage_single_output_op_amp1580
