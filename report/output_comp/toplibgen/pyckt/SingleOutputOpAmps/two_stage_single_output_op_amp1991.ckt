.suckt  two_stage_single_output_op_amp1991 ibias in1 in2 out source_nmos source_pmos
M1 net_0 in1 net_1 net_1 pmos
M2 outfirststage in2 net_1 net_1 pmos
M3 net_0 net_0 source_pmos source_pmos pmos
M4 net_2 net_0 source_pmos source_pmos pmos
M5 outfirststage bias_p_3 net_2 net_2 pmos
M6 net_4 bias_n_1b source_nmos source_nmos nmos
M7 net_0 ibias net_4 net_4 nmos
M8 net_7 bias_n_1b source_nmos source_nmos nmos
M9 outfirststage ibias net_7 net_7 nmos
M10 net_8 net_8 source_pmos source_pmos pmos
M11 net_1 net_9 net_8 net_8 pmos
M12 net_10 outfirststage source_pmos source_pmos pmos
M13 out bias_p_3 net_10 net_10 pmos
M14 net_12 bias_n_1b source_nmos source_nmos nmos
M15 out ibias net_12 net_12 nmos
M16 bias_n_1b bias_n_1b source_nmos source_nmos nmos
M17 ibias ibias bias_n_1b bias_n_1b nmos
M18 net_9 net_9 bias_p_2m bias_p_2m pmos
M19 bias_p_2m net_8 source_pmos source_pmos pmos
M20 bias_p_3 bias_p_3 source_pmos source_pmos pmos
M21 net_9 bias_n_1b source_nmos source_nmos nmos
M22 bias_p_3 bias_n_1b source_nmos source_nmos nmos
Cap_load_1 out source_nmos
Cap_compensation_1 outfirststage out
.end two_stage_single_output_op_amp1991
