.suckt  two_stage_single_output_op_amp400 ibias in1 in2 out source_nmos source_pmos
M1 net_0 in1 net_1 net_1 nmos
M2 outfirststage in2 net_1 net_1 nmos
M3 net_0 net_0 source_pmos source_pmos pmos
M4 net_2 net_0 source_pmos source_pmos pmos
M5 outfirststage bias_p_3 net_2 net_2 pmos
M6 net_4 net_4 source_nmos source_nmos nmos
M7 net_1 ibias net_4 net_4 nmos
M8 net_6 bias_p_4 source_pmos source_pmos pmos
M9 out bias_p_3 net_6 net_6 pmos
M10 net_9 outfirststage source_nmos source_nmos nmos
M11 out bias_n_2 net_9 net_9 nmos
M12 ibias ibias bias_n_1m bias_n_1m nmos
M13 bias_n_1m net_4 source_nmos source_nmos nmos
M14 bias_n_2 bias_n_2 source_nmos source_nmos nmos
M15 bias_p_3 bias_p_3 source_pmos source_pmos pmos
M16 bias_p_4 bias_p_4 source_pmos source_pmos pmos
M17 bias_p_4 net_4 source_nmos source_nmos nmos
M18 bias_n_2 bias_p_4 source_pmos source_pmos pmos
M19 bias_p_3 net_4 source_nmos source_nmos nmos
Cap_load_1 out source_nmos
Cap_compensation_1 outfirststage out
.end two_stage_single_output_op_amp400
