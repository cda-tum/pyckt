.suckt  two_stage_single_output_op_amp1185 ibias in1 in2 out source_nmos source_pmos
M1 net_0 in1 net_1 net_1 pmos
M2 net_2 in2 net_1 net_1 pmos
M3 net_3 net_4 net_0 net_0 pmos
M4 outfirststage net_4 net_2 net_2 pmos
M5 net_3 net_3 source_nmos source_nmos nmos
M6 outfirststage net_3 source_nmos source_nmos nmos
M7 net_5 bias_p_2b source_pmos source_pmos pmos
M8 net_1 bias_p_2t net_5 net_5 pmos
M9 out outfirststage source_pmos source_pmos pmos
M10 net_8 net_8 source_nmos source_nmos nmos
M11 out ibias net_8 net_8 nmos
M12 ibias ibias bias_n_1m bias_n_1m nmos
M13 bias_n_1m net_8 source_nmos source_nmos nmos
M14 net_4 net_4 net_1 net_1 pmos
M15 bias_p_2b bias_p_2b source_pmos source_pmos pmos
M16 bias_p_2t bias_p_2t bias_p_2b bias_p_2b pmos
M17 bias_p_2t net_8 source_nmos source_nmos nmos
M18 net_4 net_8 source_nmos source_nmos nmos
Cap_load_1 out source_nmos
Cap_compensation_1 outfirststage out
.end two_stage_single_output_op_amp1185
