.suckt  two_stage_single_output_op_amp359 ibias in1 in2 out source_nmos source_pmos
M1 net_0 in1 net_1 net_1 nmos
M2 outfirststage in2 net_1 net_1 nmos
M3 net_0 net_0 source_pmos source_pmos pmos
M4 outfirststage net_0 source_pmos source_pmos pmos
M5 net_2 net_2 source_nmos source_nmos nmos
M6 net_1 net_3 net_2 net_2 nmos
M7 net_4 outfirststage source_pmos source_pmos pmos
M8 out bias_p_3 net_4 net_4 pmos
M9 net_6 bias_n_2b source_nmos source_nmos nmos
M10 out ibias net_6 net_6 nmos
M11 net_3 net_3 bias_n_1m bias_n_1m nmos
M12 bias_n_1m net_2 source_nmos source_nmos nmos
M13 bias_n_2b bias_n_2b source_nmos source_nmos nmos
M14 ibias ibias bias_n_2b bias_n_2b nmos
M15 bias_p_3 bias_p_3 source_pmos source_pmos pmos
M16 bias_p_4 bias_p_4 source_pmos source_pmos pmos
M17 bias_p_3 bias_n_2b source_nmos source_nmos nmos
M18 net_3 bias_p_4 source_pmos source_pmos pmos
M19 bias_p_4 bias_n_2b source_nmos source_nmos nmos
Cap_load_1 out source_nmos
Cap_compensation_1 outfirststage out
.end two_stage_single_output_op_amp359
