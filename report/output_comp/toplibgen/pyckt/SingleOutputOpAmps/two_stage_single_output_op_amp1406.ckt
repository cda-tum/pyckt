.suckt  two_stage_single_output_op_amp1406 ibias in1 in2 out source_nmos source_pmos
M1 net_0 in1 net_1 net_1 nmos
M2 net_2 in2 net_1 net_1 nmos
M3 net_3 net_4 net_0 net_0 nmos
M4 outfirststage net_4 net_2 net_2 nmos
M5 net_3 net_3 source_pmos source_pmos pmos
M6 net_5 net_3 source_pmos source_pmos pmos
M7 outfirststage bias_p_3 net_5 net_5 pmos
M8 net_7 net_7 source_nmos source_nmos nmos
M9 net_1 net_8 net_7 net_7 nmos
M10 out ibias source_pmos source_pmos pmos
M11 net_10 outfirststage source_nmos source_nmos nmos
M12 out bias_n_2 net_10 net_10 nmos
M13 net_4 net_4 net_1 net_1 nmos
M14 net_8 net_8 bias_n_1m bias_n_1m nmos
M15 bias_n_1m net_7 source_nmos source_nmos nmos
M16 bias_n_2 bias_n_2 source_nmos source_nmos nmos
M17 bias_p_3 bias_p_3 source_pmos source_pmos pmos
M18 ibias ibias source_pmos source_pmos pmos
M19 bias_n_5 bias_n_5 source_nmos source_nmos nmos
M20 net_8 ibias source_pmos source_pmos pmos
M21 net_4 ibias source_pmos source_pmos pmos
M22 bias_n_2 ibias source_pmos source_pmos pmos
M23 bias_p_3 bias_n_5 source_nmos source_nmos nmos
M24 bias_n_5 ibias source_pmos source_pmos pmos
Cap_load_1 out source_nmos
Cap_compensation_1 outfirststage out
.end two_stage_single_output_op_amp1406
