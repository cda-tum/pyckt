.suckt  two_stage_single_output_op_amp2237 ibias in1 in2 out source_nmos source_pmos
M1 net_0 in1 net_1 net_1 nmos
M2 outfirststage in2 net_1 net_1 nmos
M3 net_0 net_2 source_nmos source_nmos nmos
M4 net_2 net_2 source_nmos source_nmos nmos
M5 outfirststage net_0 net_2 net_2 nmos
M6 net_0 bias_p_3 source_pmos source_pmos pmos
M7 outfirststage bias_p_3 source_pmos source_pmos pmos
M8 net_4 bias_n_1b source_nmos source_nmos nmos
M9 net_1 ibias net_4 net_4 nmos
M10 net_7 net_7 source_pmos source_pmos pmos
M11 out net_8 net_7 net_7 pmos
M12 out outfirststage source_nmos source_nmos nmos
M13 bias_n_1b bias_n_1b source_nmos source_nmos nmos
M14 ibias ibias bias_n_1b bias_n_1b nmos
M15 net_8 net_8 bias_p_2m bias_p_2m pmos
M16 bias_p_2m net_7 source_pmos source_pmos pmos
M17 bias_p_3 bias_p_3 source_pmos source_pmos pmos
M18 bias_p_3 bias_n_1b source_nmos source_nmos nmos
M19 net_8 bias_n_1b source_nmos source_nmos nmos
Cap_load_1 out source_nmos
Cap_compensation_1 outfirststage out
.end two_stage_single_output_op_amp2237
