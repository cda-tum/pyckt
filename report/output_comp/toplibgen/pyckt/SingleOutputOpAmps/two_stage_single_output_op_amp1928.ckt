.suckt  two_stage_single_output_op_amp1928 ibias in1 in2 out source_nmos source_pmos
M1 net_0 in1 net_1 net_1 pmos
M2 outfirststage in2 net_1 net_1 pmos
M3 net_0 net_2 source_pmos source_pmos pmos
M4 net_2 net_2 source_pmos source_pmos pmos
M5 outfirststage net_0 net_2 net_2 pmos
M6 net_3 bias_n_1b source_nmos source_nmos nmos
M7 net_0 bias_n_1t net_3 net_3 nmos
M8 net_6 bias_n_1b source_nmos source_nmos nmos
M9 outfirststage bias_n_1t net_6 net_6 nmos
M10 net_7 bias_p_2b source_pmos source_pmos pmos
M11 net_1 ibias net_7 net_7 pmos
M12 out outfirststage source_pmos source_pmos pmos
M13 net_10 bias_n_1b source_nmos source_nmos nmos
M14 out bias_n_1t net_10 net_10 nmos
M15 bias_n_1b bias_n_1b source_nmos source_nmos nmos
M16 bias_n_1t bias_n_1t bias_n_1b bias_n_1b nmos
M17 bias_p_2b bias_p_2b source_pmos source_pmos pmos
M18 ibias ibias bias_p_2b bias_p_2b pmos
M19 bias_n_1t bias_p_2b source_pmos source_pmos pmos
Cap_load_1 out source_nmos
Cap_compensation_1 outfirststage out
.end two_stage_single_output_op_amp1928
