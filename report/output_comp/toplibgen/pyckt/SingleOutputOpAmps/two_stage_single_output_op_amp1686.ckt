.suckt  two_stage_single_output_op_amp1686 ibias in1 in2 out source_nmos source_pmos
M1 net_0 in1 net_1 net_1 nmos
M2 outfirststage in2 net_1 net_1 nmos
M3 net_0 net_0 source_nmos source_nmos nmos
M4 outfirststage net_0 source_nmos source_nmos nmos
M5 net_0 bias_p_4 source_pmos source_pmos pmos
M6 outfirststage bias_p_4 source_pmos source_pmos pmos
M7 net_1 ibias source_nmos source_nmos nmos
M8 net_4 net_4 source_pmos source_pmos pmos
M9 out net_5 net_4 net_4 pmos
M10 net_6 outfirststage source_nmos source_nmos nmos
M11 out bias_n_1 net_6 net_6 nmos
M12 bias_n_1 bias_n_1 source_nmos source_nmos nmos
M13 ibias ibias source_nmos source_nmos nmos
M14 net_5 net_5 bias_p_3m bias_p_3m pmos
M15 bias_p_3m net_4 source_pmos source_pmos pmos
M16 bias_p_4 bias_p_4 source_pmos source_pmos pmos
M17 bias_p_4 ibias source_nmos source_nmos nmos
M18 bias_n_1 bias_p_4 source_pmos source_pmos pmos
M19 net_5 ibias source_nmos source_nmos nmos
Cap_load_1 out source_nmos
Cap_compensation_1 outfirststage out
.end two_stage_single_output_op_amp1686
