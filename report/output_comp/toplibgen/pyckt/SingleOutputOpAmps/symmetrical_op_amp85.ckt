.suckt  symmetrical_op_amp85 ibias in1 in2 out source_nmos source_pmos
M1 out2fs in1 net_0 net_0 pmos
M2 inoutputtc in2 net_0 net_0 pmos
M3 out1fs out1fs source_nmos source_nmos nmos
M4 out2fs out2fs out1fs out1fs nmos
M5 insourcetc insourcetc source_nmos source_nmos nmos
M6 inoutputtc inoutputtc insourcetc insourcetc nmos
M7 net_0 ibias source_pmos source_pmos pmos
M8 out instagebias source_pmos source_pmos pmos
M9 net_2 out1fs source_nmos source_nmos nmos
M10 out out2fs net_2 net_2 nmos
M11 net_3 insourcetc source_nmos source_nmos nmos
M12 instagebias inoutputtc net_3 net_3 nmos
M13 instagebias instagebias source_pmos source_pmos pmos
M14 ibias ibias source_pmos source_pmos pmos
Cap_load_1 out source_nmos
.end symmetrical_op_amp85
