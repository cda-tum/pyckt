.suckt  two_stage_single_output_op_amp1295 ibias in1 in2 out source_nmos source_pmos
M1 net_0 in1 net_1 net_1 pmos
M2 net_2 in2 net_1 net_1 pmos
M3 net_3 net_4 net_0 net_0 pmos
M4 outfirststage net_4 net_2 net_2 pmos
M5 net_5 net_3 source_nmos source_nmos nmos
M6 net_3 bias_n_1 net_5 net_5 nmos
M7 net_7 net_3 source_nmos source_nmos nmos
M8 outfirststage bias_n_1 net_7 net_7 nmos
M9 net_8 net_8 source_pmos source_pmos pmos
M10 net_1 net_9 net_8 net_8 pmos
M11 net_10 outfirststage source_pmos source_pmos pmos
M12 out bias_p_4 net_10 net_10 pmos
M13 net_12 ibias source_nmos source_nmos nmos
M14 out bias_n_1 net_12 net_12 nmos
M15 bias_n_1 bias_n_1 source_nmos source_nmos nmos
M16 ibias ibias source_nmos source_nmos nmos
M17 net_4 net_4 net_1 net_1 pmos
M18 net_9 net_9 bias_p_3m bias_p_3m pmos
M19 bias_p_3m net_8 source_pmos source_pmos pmos
M20 bias_p_4 bias_p_4 source_pmos source_pmos pmos
M21 bias_p_5 bias_p_5 source_pmos source_pmos pmos
M22 net_9 ibias source_nmos source_nmos nmos
M23 bias_n_1 bias_p_5 source_pmos source_pmos pmos
M24 net_4 ibias source_nmos source_nmos nmos
M25 bias_p_4 ibias source_nmos source_nmos nmos
M26 bias_p_5 ibias source_nmos source_nmos nmos
Cap_load_1 out source_nmos
Cap_compensation_1 outfirststage out
.end two_stage_single_output_op_amp1295
