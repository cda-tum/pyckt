.suckt  one_stage_single_output_op_amp92 ibias in1 in2 out source_nmos source_pmos
M1 net_0 in1 net_1 net_1 nmos
M2 net_2 in2 net_1 net_1 nmos
M3 net_3 net_4 net_0 net_0 nmos
M4 out net_4 net_2 net_2 nmos
M5 net_3 net_3 source_pmos source_pmos pmos
M6 out net_3 source_pmos source_pmos pmos
M7 net_1 ibias source_nmos source_nmos nmos
M8 net_4 net_4 net_1 net_1 nmos
M9 ibias ibias source_nmos source_nmos nmos
M10 bias_p_2 bias_p_2 source_pmos source_pmos pmos
M11 net_4 bias_p_2 source_pmos source_pmos pmos
M12 bias_p_2 ibias source_nmos source_nmos nmos
Cap_load_1 out source_nmos
.end one_stage_single_output_op_amp92
