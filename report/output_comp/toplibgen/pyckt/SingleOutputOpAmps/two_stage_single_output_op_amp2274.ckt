.suckt  two_stage_single_output_op_amp2274 ibias in1 in2 out source_nmos source_pmos
M1 net_0 in1 net_1 net_1 nmos
M2 outfirststage in2 net_1 net_1 nmos
M3 net_0 net_2 source_nmos source_nmos nmos
M4 net_2 net_2 source_nmos source_nmos nmos
M5 outfirststage net_0 net_2 net_2 nmos
M6 net_3 bias_p_4b source_pmos source_pmos pmos
M7 net_0 bias_p_4t net_3 net_3 pmos
M8 net_6 bias_p_4b source_pmos source_pmos pmos
M9 outfirststage bias_p_4t net_6 net_6 pmos
M10 net_7 net_7 source_nmos source_nmos nmos
M11 net_1 ibias net_7 net_7 nmos
M12 net_9 net_9 source_pmos source_pmos pmos
M13 out net_10 net_9 net_9 pmos
M14 net_11 outfirststage source_nmos source_nmos nmos
M15 out bias_n_2 net_11 net_11 nmos
M16 ibias ibias bias_n_1m bias_n_1m nmos
M17 bias_n_1m net_7 source_nmos source_nmos nmos
M18 bias_n_2 bias_n_2 source_nmos source_nmos nmos
M19 net_10 net_10 bias_p_3m bias_p_3m pmos
M20 bias_p_3m net_9 source_pmos source_pmos pmos
M21 bias_p_4b bias_p_4b source_pmos source_pmos pmos
M22 bias_p_4t bias_p_4t bias_p_4b bias_p_4b pmos
M23 bias_p_4t net_7 source_nmos source_nmos nmos
M24 bias_n_2 bias_p_4b source_pmos source_pmos pmos
M25 net_10 net_7 source_nmos source_nmos nmos
Cap_load_1 out source_nmos
Cap_compensation_1 outfirststage out
.end two_stage_single_output_op_amp2274
