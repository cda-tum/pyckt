.suckt  two_stage_single_output_op_amp278 ibias in1 in2 out source_nmos source_pmos
M1 net_0 in1 net_1 net_1 pmos
M2 outfirststage in2 net_1 net_1 pmos
M3 net_2 net_0 source_nmos source_nmos nmos
M4 net_0 bias_n_1 net_2 net_2 nmos
M5 net_4 net_0 source_nmos source_nmos nmos
M6 outfirststage bias_n_1 net_4 net_4 nmos
M7 net_5 net_5 source_pmos source_pmos pmos
M8 net_1 net_6 net_5 net_5 pmos
M9 out ibias source_pmos source_pmos pmos
M10 net_8 outfirststage source_nmos source_nmos nmos
M11 out bias_n_1 net_8 net_8 nmos
M12 bias_n_1 bias_n_1 source_nmos source_nmos nmos
M13 net_6 net_6 bias_p_2m bias_p_2m pmos
M14 bias_p_2m net_5 source_pmos source_pmos pmos
M15 ibias ibias source_pmos source_pmos pmos
M16 bias_n_4 bias_n_4 source_nmos source_nmos nmos
M17 bias_n_1 ibias source_pmos source_pmos pmos
M18 net_6 bias_n_4 source_nmos source_nmos nmos
M19 bias_n_4 ibias source_pmos source_pmos pmos
Cap_load_1 out source_nmos
Cap_compensation_1 outfirststage out
.end two_stage_single_output_op_amp278
