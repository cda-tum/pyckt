.suckt  two_stage_single_output_op_amp934 ibias in1 in2 out source_nmos source_pmos
M1 net_0 in1 net_1 net_1 nmos
M2 net_2 in2 net_1 net_1 nmos
M3 net_0 bias_p_4 source_pmos source_pmos pmos
M4 net_4 bias_p_3 net_0 net_0 pmos
M5 net_2 bias_p_4 source_pmos source_pmos pmos
M6 outfirststage bias_p_3 net_2 net_2 pmos
M7 net_6 net_6 source_nmos source_nmos nmos
M8 net_4 net_4 net_6 net_6 nmos
M9 net_7 net_6 source_nmos source_nmos nmos
M10 outfirststage net_4 net_7 net_7 nmos
M11 net_8 net_8 source_nmos source_nmos nmos
M12 net_1 net_9 net_8 net_8 nmos
M13 net_10 outfirststage source_pmos source_pmos pmos
M14 out bias_p_3 net_10 net_10 pmos
M15 out ibias source_nmos source_nmos nmos
M16 net_9 net_9 bias_n_1m bias_n_1m nmos
M17 bias_n_1m net_8 source_nmos source_nmos nmos
M18 ibias ibias source_nmos source_nmos nmos
M19 bias_p_3 bias_p_3 source_pmos source_pmos pmos
M20 bias_p_4 bias_p_4 source_pmos source_pmos pmos
M21 bias_p_4 ibias source_nmos source_nmos nmos
M22 bias_p_3 ibias source_nmos source_nmos nmos
M23 net_9 bias_p_4 source_pmos source_pmos pmos
Cap_load_1 out source_nmos
Cap_compensation_1 outfirststage out
.end two_stage_single_output_op_amp934
