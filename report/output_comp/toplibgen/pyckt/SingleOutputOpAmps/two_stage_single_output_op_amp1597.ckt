.suckt  two_stage_single_output_op_amp1597 ibias in1 in2 out source_nmos source_pmos
M1 net_0 in1 net_1 net_1 pmos
M2 outfirststage in2 net_1 net_1 pmos
M3 net_2 net_2 source_pmos source_pmos pmos
M4 net_0 net_0 net_2 net_2 pmos
M5 net_3 net_2 source_pmos source_pmos pmos
M6 outfirststage net_0 net_3 net_3 pmos
M7 net_4 bias_n_1b source_nmos source_nmos nmos
M8 net_0 bias_n_1t net_4 net_4 nmos
M9 net_7 bias_n_1b source_nmos source_nmos nmos
M10 outfirststage bias_n_1t net_7 net_7 nmos
M11 net_1 ibias source_pmos source_pmos pmos
M12 out ibias source_pmos source_pmos pmos
M13 out outfirststage source_nmos source_nmos nmos
M14 bias_n_1b bias_n_1b source_nmos source_nmos nmos
M15 bias_n_1t bias_n_1t bias_n_1b bias_n_1b nmos
M16 ibias ibias source_pmos source_pmos pmos
M17 bias_n_1t ibias source_pmos source_pmos pmos
Cap_load_1 out source_nmos
Cap_compensation_1 outfirststage out
.end two_stage_single_output_op_amp1597
