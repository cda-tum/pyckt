.suckt  two_stage_single_output_op_amp2070 ibias in1 in2 out source_nmos source_pmos
M1 net_0 in1 net_1 net_1 pmos
M2 outfirststage in2 net_1 net_1 pmos
M3 net_2 net_0 source_pmos source_pmos pmos
M4 net_0 bias_p_4 net_2 net_2 pmos
M5 net_4 net_0 source_pmos source_pmos pmos
M6 outfirststage bias_p_4 net_4 net_4 pmos
M7 net_5 ibias source_nmos source_nmos nmos
M8 net_0 bias_n_1 net_5 net_5 nmos
M9 net_8 ibias source_nmos source_nmos nmos
M10 outfirststage bias_n_1 net_8 net_8 nmos
M11 net_9 bias_p_5 source_pmos source_pmos pmos
M12 net_1 bias_p_4 net_9 net_9 pmos
M13 net_12 net_12 source_pmos source_pmos pmos
M14 out net_13 net_12 net_12 pmos
M15 net_14 outfirststage source_nmos source_nmos nmos
M16 out bias_n_1 net_14 net_14 nmos
M17 bias_n_1 bias_n_1 source_nmos source_nmos nmos
M18 ibias ibias source_nmos source_nmos nmos
M19 net_13 net_13 bias_p_3m bias_p_3m pmos
M20 bias_p_3m net_12 source_pmos source_pmos pmos
M21 bias_p_4 bias_p_4 source_pmos source_pmos pmos
M22 bias_p_5 bias_p_5 source_pmos source_pmos pmos
M23 bias_p_5 ibias source_nmos source_nmos nmos
M24 bias_n_1 bias_p_5 source_pmos source_pmos pmos
M25 bias_p_4 ibias source_nmos source_nmos nmos
M26 net_13 ibias source_nmos source_nmos nmos
Cap_load_1 out source_nmos
Cap_compensation_1 outfirststage out
.end two_stage_single_output_op_amp2070
