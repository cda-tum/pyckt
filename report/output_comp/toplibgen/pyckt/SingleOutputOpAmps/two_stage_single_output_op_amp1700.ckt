.suckt  two_stage_single_output_op_amp1700 ibias in1 in2 out source_nmos source_pmos
M1 net_0 in1 net_1 net_1 nmos
M2 outfirststage in2 net_1 net_1 nmos
M3 net_0 net_0 source_nmos source_nmos nmos
M4 outfirststage net_0 source_nmos source_nmos nmos
M5 net_2 bias_p_3b source_pmos source_pmos pmos
M6 net_0 ibias net_2 net_2 pmos
M7 net_5 bias_p_3b source_pmos source_pmos pmos
M8 outfirststage ibias net_5 net_5 pmos
M9 net_1 bias_n_2 source_nmos source_nmos nmos
M10 out outfirststage source_pmos source_pmos pmos
M11 net_7 bias_n_2 source_nmos source_nmos nmos
M12 out bias_n_1 net_7 net_7 nmos
M13 bias_n_1 bias_n_1 source_nmos source_nmos nmos
M14 bias_n_2 bias_n_2 source_nmos source_nmos nmos
M15 bias_p_3b bias_p_3b source_pmos source_pmos pmos
M16 ibias ibias bias_p_3b bias_p_3b pmos
M17 bias_n_2 bias_p_3b source_pmos source_pmos pmos
M18 bias_n_1 bias_p_3b source_pmos source_pmos pmos
Cap_load_1 out source_nmos
Cap_compensation_1 outfirststage out
.end two_stage_single_output_op_amp1700
