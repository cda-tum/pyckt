.suckt  two_stage_single_output_op_amp1293 ibias in1 in2 out source_nmos source_pmos
M1 net_0 in1 net_1 net_1 pmos
M2 net_2 in2 net_1 net_1 pmos
M3 net_3 net_4 net_0 net_0 pmos
M4 outfirststage net_4 net_2 net_2 pmos
M5 net_5 net_3 source_nmos source_nmos nmos
M6 net_3 bias_n_2 net_5 net_5 nmos
M7 net_7 net_3 source_nmos source_nmos nmos
M8 outfirststage bias_n_2 net_7 net_7 nmos
M9 net_8 net_8 source_pmos source_pmos pmos
M10 net_1 ibias net_8 net_8 pmos
M11 out outfirststage source_pmos source_pmos pmos
M12 net_10 net_10 source_nmos source_nmos nmos
M13 out net_11 net_10 net_10 nmos
M14 net_11 net_11 bias_n_1m bias_n_1m nmos
M15 bias_n_1m net_10 source_nmos source_nmos nmos
M16 bias_n_2 bias_n_2 source_nmos source_nmos nmos
M17 net_4 net_4 net_1 net_1 pmos
M18 ibias ibias bias_p_3m bias_p_3m pmos
M19 bias_p_3m net_8 source_pmos source_pmos pmos
M20 bias_n_4 bias_n_4 source_nmos source_nmos nmos
M21 net_11 net_8 source_pmos source_pmos pmos
M22 bias_n_2 net_8 source_pmos source_pmos pmos
M23 net_4 bias_n_4 source_nmos source_nmos nmos
M24 bias_n_4 net_8 source_pmos source_pmos pmos
Cap_load_1 out source_nmos
Cap_compensation_1 outfirststage out
.end two_stage_single_output_op_amp1293
