.suckt  two_stage_single_output_op_amp1460 ibias in1 in2 out source_nmos source_pmos
M1 net_0 in1 net_1 net_1 nmos
M2 net_2 in2 net_1 net_1 nmos
M3 net_3 net_4 net_0 net_0 nmos
M4 outfirststage net_4 net_2 net_2 nmos
M5 net_5 net_3 source_pmos source_pmos pmos
M6 net_3 bias_p_3 net_5 net_5 pmos
M7 net_7 net_3 source_pmos source_pmos pmos
M8 outfirststage bias_p_3 net_7 net_7 pmos
M9 net_8 net_8 source_nmos source_nmos nmos
M10 net_1 net_9 net_8 net_8 nmos
M11 out outfirststage source_pmos source_pmos pmos
M12 net_10 bias_n_2b source_nmos source_nmos nmos
M13 out ibias net_10 net_10 nmos
M14 net_4 net_4 net_1 net_1 nmos
M15 net_9 net_9 bias_n_1m bias_n_1m nmos
M16 bias_n_1m net_8 source_nmos source_nmos nmos
M17 bias_n_2b bias_n_2b source_nmos source_nmos nmos
M18 ibias ibias bias_n_2b bias_n_2b nmos
M19 bias_p_3 bias_p_3 source_pmos source_pmos pmos
M20 bias_p_4 bias_p_4 source_pmos source_pmos pmos
M21 net_4 bias_p_4 source_pmos source_pmos pmos
M22 bias_p_3 bias_n_2b source_nmos source_nmos nmos
M23 net_9 bias_p_4 source_pmos source_pmos pmos
M24 bias_p_4 bias_n_2b source_nmos source_nmos nmos
Cap_load_1 out source_nmos
Cap_compensation_1 outfirststage out
.end two_stage_single_output_op_amp1460
