.suckt  symmetrical_op_amp114 ibias in1 in2 out source_nmos source_pmos
M1 out1fs in1 net_0 net_0 nmos
M2 insourcetc in2 net_0 net_0 nmos
M3 net_1 out1fs source_pmos source_pmos pmos
M4 out1fs bias_p_3 net_1 net_1 pmos
M5 net_2 insourcetc source_pmos source_pmos pmos
M6 insourcetc bias_p_3 net_2 net_2 pmos
M7 net_0 ibias source_nmos source_nmos nmos
M8 net_4 out1fs source_pmos source_pmos pmos
M9 out bias_p_3 net_4 net_4 pmos
M10 net_5 instagebias source_nmos source_nmos nmos
M11 out bias_n_1 net_5 net_5 nmos
M12 net_7 insourcetc source_pmos source_pmos pmos
M13 instagebias bias_p_3 net_7 net_7 pmos
M14 instagebias instagebias source_nmos source_nmos nmos
M15 bias_n_1 bias_n_1 source_nmos source_nmos nmos
M16 ibias ibias source_nmos source_nmos nmos
M17 bias_p_3 bias_p_3 source_pmos source_pmos pmos
M18 bias_p_4 bias_p_4 source_pmos source_pmos pmos
M19 bias_n_1 bias_p_4 source_pmos source_pmos pmos
M20 bias_p_3 ibias source_nmos source_nmos nmos
M21 bias_p_4 ibias source_nmos source_nmos nmos
Cap_load_1 out source_nmos
.end symmetrical_op_amp114
