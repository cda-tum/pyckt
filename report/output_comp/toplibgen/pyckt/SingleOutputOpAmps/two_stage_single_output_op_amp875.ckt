.suckt  two_stage_single_output_op_amp875 ibias in1 in2 out source_nmos source_pmos
M1 net_0 in1 net_1 net_1 nmos
M2 net_2 in2 net_1 net_1 nmos
M3 net_0 bias_p_3 source_pmos source_pmos pmos
M4 net_4 bias_p_2 net_0 net_0 pmos
M5 net_2 bias_p_3 source_pmos source_pmos pmos
M6 outfirststage bias_p_2 net_2 net_2 pmos
M7 net_4 net_6 source_nmos source_nmos nmos
M8 net_6 net_6 source_nmos source_nmos nmos
M9 outfirststage net_4 net_6 net_6 nmos
M10 net_7 bias_n_1b source_nmos source_nmos nmos
M11 net_1 ibias net_7 net_7 nmos
M12 net_10 outfirststage source_pmos source_pmos pmos
M13 out bias_p_2 net_10 net_10 pmos
M14 net_12 bias_n_1b source_nmos source_nmos nmos
M15 out ibias net_12 net_12 nmos
M16 bias_n_1b bias_n_1b source_nmos source_nmos nmos
M17 ibias ibias bias_n_1b bias_n_1b nmos
M18 bias_p_2 bias_p_2 source_pmos source_pmos pmos
M19 bias_p_3 bias_p_3 source_pmos source_pmos pmos
M20 bias_p_3 bias_n_1b source_nmos source_nmos nmos
M21 bias_p_2 bias_n_1b source_nmos source_nmos nmos
Cap_load_1 out source_nmos
Cap_compensation_1 outfirststage out
.end two_stage_single_output_op_amp875
