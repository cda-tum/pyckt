.suckt  one_stage_single_output_op_amp134 ibias in1 in2 out source_nmos source_pmos
M1 net_0 in1 net_1 net_1 pmos
M2 out in2 net_1 net_1 pmos
M3 net_2 net_2 source_pmos source_pmos pmos
M4 net_0 net_0 net_2 net_2 pmos
M5 net_3 net_2 source_pmos source_pmos pmos
M6 out net_0 net_3 net_3 pmos
M7 net_4 bias_n_1b source_nmos source_nmos nmos
M8 net_0 bias_n_1t net_4 net_4 nmos
M9 net_7 bias_n_1b source_nmos source_nmos nmos
M10 out bias_n_1t net_7 net_7 nmos
M11 net_1 ibias source_pmos source_pmos pmos
M12 bias_n_1b bias_n_1b source_nmos source_nmos nmos
M13 bias_n_1t bias_n_1t bias_n_1b bias_n_1b nmos
M14 ibias ibias source_pmos source_pmos pmos
M15 bias_n_1t ibias source_pmos source_pmos pmos
Cap_load_1 out source_nmos
.end one_stage_single_output_op_amp134
