.suckt  symmetrical_op_amp64 ibias in1 in2 out source_nmos source_pmos
M1 out1fs in1 net_0 net_0 nmos
M2 out2fs in2 net_0 net_0 nmos
M3 out1fs out1fs source_pmos source_pmos pmos
M4 out2fs out2fs source_pmos source_pmos pmos
M5 net_1 bias_n_1b source_nmos source_nmos nmos
M6 net_0 ibias net_1 net_1 nmos
M7 net_4 out1fs source_pmos source_pmos pmos
M8 out bias_p_2 net_4 net_4 pmos
M9 out instagebias source_nmos source_nmos nmos
M10 net_5 out2fs source_pmos source_pmos pmos
M11 instagebias bias_p_2 net_5 net_5 pmos
M12 instagebias instagebias source_nmos source_nmos nmos
M13 bias_n_1b bias_n_1b source_nmos source_nmos nmos
M14 ibias ibias bias_n_1b bias_n_1b nmos
M15 bias_p_2 bias_p_2 source_pmos source_pmos pmos
M16 bias_p_2 bias_n_1b source_nmos source_nmos nmos
Cap_load_1 out source_nmos
.end symmetrical_op_amp64
