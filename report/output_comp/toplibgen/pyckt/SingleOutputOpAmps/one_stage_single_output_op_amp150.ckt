.suckt  one_stage_single_output_op_amp150 ibias in1 in2 out source_nmos source_pmos
M1 net_0 in1 net_1 net_1 nmos
M2 out in2 net_1 net_1 nmos
M3 net_2 net_0 source_nmos source_nmos nmos
M4 net_0 bias_n_1 net_2 net_2 nmos
M5 net_4 net_0 source_nmos source_nmos nmos
M6 out bias_n_1 net_4 net_4 nmos
M7 net_5 bias_p_3b source_pmos source_pmos pmos
M8 net_0 ibias net_5 net_5 pmos
M9 net_8 bias_p_3b source_pmos source_pmos pmos
M10 out ibias net_8 net_8 pmos
M11 net_1 bias_n_2 source_nmos source_nmos nmos
M12 bias_n_1 bias_n_1 source_nmos source_nmos nmos
M13 bias_n_2 bias_n_2 source_nmos source_nmos nmos
M14 bias_p_3b bias_p_3b source_pmos source_pmos pmos
M15 ibias ibias bias_p_3b bias_p_3b pmos
M16 bias_n_2 bias_p_3b source_pmos source_pmos pmos
M17 bias_n_1 bias_p_3b source_pmos source_pmos pmos
Cap_load_1 out source_nmos
.end one_stage_single_output_op_amp150
