.suckt  two_stage_single_output_op_amp215 ibias in1 in2 out source_nmos source_pmos
M1 net_0 in1 net_1 net_1 pmos
M2 outfirststage in2 net_1 net_1 pmos
M3 net_0 net_2 source_nmos source_nmos nmos
M4 net_2 net_2 source_nmos source_nmos nmos
M5 outfirststage net_0 net_2 net_2 nmos
M6 net_3 net_3 source_pmos source_pmos pmos
M7 net_1 net_4 net_3 net_3 pmos
M8 net_5 outfirststage source_pmos source_pmos pmos
M9 out bias_p_3 net_5 net_5 pmos
M10 net_7 bias_n_1b source_nmos source_nmos nmos
M11 out ibias net_7 net_7 nmos
M12 bias_n_1b bias_n_1b source_nmos source_nmos nmos
M13 ibias ibias bias_n_1b bias_n_1b nmos
M14 net_4 net_4 bias_p_2m bias_p_2m pmos
M15 bias_p_2m net_3 source_pmos source_pmos pmos
M16 bias_p_3 bias_p_3 source_pmos source_pmos pmos
M17 net_4 bias_n_1b source_nmos source_nmos nmos
M18 bias_p_3 bias_n_1b source_nmos source_nmos nmos
Cap_load_1 out source_nmos
Cap_compensation_1 outfirststage out
.end two_stage_single_output_op_amp215
