.suckt  two_stage_single_output_op_amp1977 ibias in1 in2 out source_nmos source_pmos
M1 net_0 in1 net_1 net_1 pmos
M2 outfirststage in2 net_1 net_1 pmos
M3 net_0 net_0 source_pmos source_pmos pmos
M4 net_2 net_0 source_pmos source_pmos pmos
M5 outfirststage bias_p_3 net_2 net_2 pmos
M6 net_4 bias_n_2b source_nmos source_nmos nmos
M7 net_0 bias_n_2t net_4 net_4 nmos
M8 net_7 bias_n_2b source_nmos source_nmos nmos
M9 outfirststage bias_n_2t net_7 net_7 nmos
M10 net_8 ibias source_pmos source_pmos pmos
M11 net_1 bias_p_3 net_8 net_8 pmos
M12 out outfirststage source_pmos source_pmos pmos
M13 net_11 net_11 source_nmos source_nmos nmos
M14 out net_12 net_11 net_11 nmos
M15 net_12 net_12 bias_n_1m bias_n_1m nmos
M16 bias_n_1m net_11 source_nmos source_nmos nmos
M17 bias_n_2b bias_n_2b source_nmos source_nmos nmos
M18 bias_n_2t bias_n_2t bias_n_2b bias_n_2b nmos
M19 bias_p_3 bias_p_3 source_pmos source_pmos pmos
M20 ibias ibias source_pmos source_pmos pmos
M21 bias_n_2t ibias source_pmos source_pmos pmos
M22 bias_p_3 bias_n_2b source_nmos source_nmos nmos
M23 net_12 ibias source_pmos source_pmos pmos
Cap_load_1 out source_nmos
Cap_compensation_1 outfirststage out
.end two_stage_single_output_op_amp1977
