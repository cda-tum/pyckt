.suckt  two_stage_single_output_op_amp2262 ibias in1 in2 out source_nmos source_pmos
M1 net_0 in1 net_1 net_1 nmos
M2 outfirststage in2 net_1 net_1 nmos
M3 net_0 net_2 source_nmos source_nmos nmos
M4 net_2 net_2 source_nmos source_nmos nmos
M5 outfirststage net_0 net_2 net_2 nmos
M6 net_3 bias_p_4b source_pmos source_pmos pmos
M7 net_0 bias_p_4t net_3 net_3 pmos
M8 net_6 bias_p_4b source_pmos source_pmos pmos
M9 outfirststage bias_p_4t net_6 net_6 pmos
M10 net_7 ibias source_nmos source_nmos nmos
M11 net_1 bias_n_1 net_7 net_7 nmos
M12 net_10 net_10 source_pmos source_pmos pmos
M13 out net_11 net_10 net_10 pmos
M14 net_12 outfirststage source_nmos source_nmos nmos
M15 out bias_n_1 net_12 net_12 nmos
M16 bias_n_1 bias_n_1 source_nmos source_nmos nmos
M17 ibias ibias source_nmos source_nmos nmos
M18 net_11 net_11 bias_p_3m bias_p_3m pmos
M19 bias_p_3m net_10 source_pmos source_pmos pmos
M20 bias_p_4b bias_p_4b source_pmos source_pmos pmos
M21 bias_p_4t bias_p_4t bias_p_4b bias_p_4b pmos
M22 bias_p_4t ibias source_nmos source_nmos nmos
M23 bias_n_1 bias_p_4b source_pmos source_pmos pmos
M24 net_11 ibias source_nmos source_nmos nmos
Cap_load_1 out source_nmos
Cap_compensation_1 outfirststage out
.end two_stage_single_output_op_amp2262
