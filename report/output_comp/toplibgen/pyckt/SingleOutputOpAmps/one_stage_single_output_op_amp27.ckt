.suckt  one_stage_single_output_op_amp27 ibias in1 in2 out source_nmos source_pmos
M1 net_0 in1 net_1 net_1 pmos
M2 out in2 net_1 net_1 pmos
M3 net_2 net_0 source_nmos source_nmos nmos
M4 net_0 net_0 net_2 net_2 nmos
M5 net_3 net_0 source_nmos source_nmos nmos
M6 out net_0 net_3 net_3 nmos
M7 net_4 bias_p_1b source_pmos source_pmos pmos
M8 net_1 ibias net_4 net_4 pmos
M9 bias_p_1b bias_p_1b source_pmos source_pmos pmos
M10 ibias ibias bias_p_1b bias_p_1b pmos
Cap_load_1 out source_nmos
.end one_stage_single_output_op_amp27
