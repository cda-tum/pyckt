.suckt  one_stage_single_output_op_amp154 ibias in1 in2 out source_nmos source_pmos
M1 net_0 in1 net_1 net_1 nmos
M2 out in2 net_1 net_1 nmos
M3 net_2 net_0 source_nmos source_nmos nmos
M4 net_0 net_0 net_2 net_2 nmos
M5 net_3 net_0 source_nmos source_nmos nmos
M6 out net_0 net_3 net_3 nmos
M7 net_4 bias_p_2b source_pmos source_pmos pmos
M8 net_0 bias_p_2t net_4 net_4 pmos
M9 net_7 bias_p_2b source_pmos source_pmos pmos
M10 out bias_p_2t net_7 net_7 pmos
M11 net_1 ibias source_nmos source_nmos nmos
M12 ibias ibias source_nmos source_nmos nmos
M13 bias_p_2b bias_p_2b source_pmos source_pmos pmos
M14 bias_p_2t bias_p_2t bias_p_2b bias_p_2b pmos
M15 bias_p_2t ibias source_nmos source_nmos nmos
Cap_load_1 out source_nmos
.end one_stage_single_output_op_amp154
