.suckt  one_stage_single_output_op_amp189 ibias in1 in2 out source_nmos source_pmos
M1 net_0 in1 net_1 net_1 nmos
M2 out in2 net_1 net_1 nmos
M3 net_0 net_2 source_nmos source_nmos nmos
M4 net_2 net_2 source_nmos source_nmos nmos
M5 out net_0 net_2 net_2 nmos
M6 net_3 bias_p_2b source_pmos source_pmos pmos
M7 net_0 bias_p_2t net_3 net_3 pmos
M8 net_6 bias_p_2b source_pmos source_pmos pmos
M9 out bias_p_2t net_6 net_6 pmos
M10 net_7 bias_n_1b source_nmos source_nmos nmos
M11 net_1 ibias net_7 net_7 nmos
M12 bias_n_1b bias_n_1b source_nmos source_nmos nmos
M13 ibias ibias bias_n_1b bias_n_1b nmos
M14 bias_p_2b bias_p_2b source_pmos source_pmos pmos
M15 bias_p_2t bias_p_2t bias_p_2b bias_p_2b pmos
M16 bias_p_2t bias_n_1b source_nmos source_nmos nmos
Cap_load_1 out source_nmos
.end one_stage_single_output_op_amp189
