.suckt  two_stage_single_output_op_amp2241 ibias in1 in2 out source_nmos source_pmos
M1 net_0 in1 net_1 net_1 nmos
M2 outfirststage in2 net_1 net_1 nmos
M3 net_0 net_2 source_nmos source_nmos nmos
M4 net_2 net_2 source_nmos source_nmos nmos
M5 outfirststage net_0 net_2 net_2 nmos
M6 net_0 ibias source_pmos source_pmos pmos
M7 outfirststage ibias source_pmos source_pmos pmos
M8 net_4 bias_n_2b source_nmos source_nmos nmos
M9 net_1 bias_n_2t net_4 net_4 nmos
M10 out outfirststage source_pmos source_pmos pmos
M11 net_7 net_7 source_nmos source_nmos nmos
M12 out net_8 net_7 net_7 nmos
M13 net_8 net_8 bias_n_1m bias_n_1m nmos
M14 bias_n_1m net_7 source_nmos source_nmos nmos
M15 bias_n_2b bias_n_2b source_nmos source_nmos nmos
M16 bias_n_2t bias_n_2t bias_n_2b bias_n_2b nmos
M17 ibias ibias source_pmos source_pmos pmos
M18 bias_n_2t ibias source_pmos source_pmos pmos
M19 net_8 ibias source_pmos source_pmos pmos
Cap_load_1 out source_nmos
Cap_compensation_1 outfirststage out
.end two_stage_single_output_op_amp2241
