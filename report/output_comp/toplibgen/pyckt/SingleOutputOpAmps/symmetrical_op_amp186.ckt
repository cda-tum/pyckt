.suckt  symmetrical_op_amp186 ibias in1 in2 out source_nmos source_pmos
M1 out1fs in1 net_0 net_0 nmos
M2 insourcetc in2 net_0 net_0 nmos
M3 net_1 out1fs source_pmos source_pmos pmos
M4 out1fs bias_p_3 net_1 net_1 pmos
M5 net_2 insourcetc source_pmos source_pmos pmos
M6 insourcetc bias_p_3 net_2 net_2 pmos
M7 net_3 ibias source_nmos source_nmos nmos
M8 net_0 bias_n_1 net_3 net_3 nmos
M9 net_6 out1fs source_pmos source_pmos pmos
M10 out bias_p_3 net_6 net_6 pmos
M11 net_7 insourcestagebias source_nmos source_nmos nmos
M12 out bias_n_1 net_7 net_7 nmos
M13 net_8 insourcetc source_pmos source_pmos pmos
M14 insourcestagebias bias_p_3 net_8 net_8 pmos
M15 net_9 insourcestagebias source_nmos source_nmos nmos
M16 insourcestagebias bias_n_1 net_9 net_9 nmos
M17 bias_n_1 bias_n_1 source_nmos source_nmos nmos
M18 ibias ibias source_nmos source_nmos nmos
M19 bias_p_3 bias_p_3 source_pmos source_pmos pmos
M20 bias_p_4 bias_p_4 source_pmos source_pmos pmos
M21 bias_n_1 bias_p_4 source_pmos source_pmos pmos
M22 bias_p_3 ibias source_nmos source_nmos nmos
M23 bias_p_4 ibias source_nmos source_nmos nmos
Cap_load_1 out source_nmos
.end symmetrical_op_amp186
