.suckt  two_stage_single_output_op_amp2139 ibias in1 in2 out source_nmos source_pmos
M1 net_0 in1 net_1 net_1 pmos
M2 outfirststage in2 net_1 net_1 pmos
M3 net_2 net_0 source_pmos source_pmos pmos
M4 net_0 net_0 net_2 net_2 pmos
M5 net_3 net_0 source_pmos source_pmos pmos
M6 outfirststage net_0 net_3 net_3 pmos
M7 net_0 bias_n_1 source_nmos source_nmos nmos
M8 outfirststage bias_n_1 source_nmos source_nmos nmos
M9 net_5 bias_p_2b source_pmos source_pmos pmos
M10 net_1 ibias net_5 net_5 pmos
M11 net_8 bias_p_2b source_pmos source_pmos pmos
M12 out ibias net_8 net_8 pmos
M13 out outfirststage source_nmos source_nmos nmos
M14 bias_n_1 bias_n_1 source_nmos source_nmos nmos
M15 bias_p_2b bias_p_2b source_pmos source_pmos pmos
M16 ibias ibias bias_p_2b bias_p_2b pmos
M17 bias_n_1 bias_p_2b source_pmos source_pmos pmos
Cap_load_1 out source_nmos
Cap_compensation_1 outfirststage out
.end two_stage_single_output_op_amp2139
