.suckt  two_stage_single_output_op_amp28 ibias in1 in2 out source_nmos source_pmos
M1 net_0 in1 net_1 net_1 pmos
M2 outfirststage in2 net_1 net_1 pmos
M3 net_0 net_0 source_nmos source_nmos nmos
M4 net_2 net_0 source_nmos source_nmos nmos
M5 outfirststage bias_n_1 net_2 net_2 nmos
M6 net_1 ibias source_pmos source_pmos pmos
M7 net_5 ibias source_pmos source_pmos pmos
M8 out bias_p_2 net_5 net_5 pmos
M9 net_8 outfirststage source_nmos source_nmos nmos
M10 out bias_n_1 net_8 net_8 nmos
M11 bias_n_1 bias_n_1 source_nmos source_nmos nmos
M12 bias_p_2 bias_p_2 source_pmos source_pmos pmos
M13 ibias ibias source_pmos source_pmos pmos
M14 bias_n_4 bias_n_4 source_nmos source_nmos nmos
M15 bias_n_1 ibias source_pmos source_pmos pmos
M16 bias_p_2 bias_n_4 source_nmos source_nmos nmos
M17 bias_n_4 ibias source_pmos source_pmos pmos
Cap_load_1 out source_nmos
Cap_compensation_1 outfirststage out
.end two_stage_single_output_op_amp28
