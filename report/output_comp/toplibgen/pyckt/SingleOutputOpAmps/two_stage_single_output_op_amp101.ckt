.suckt  two_stage_single_output_op_amp101 ibias in1 in2 out source_nmos source_pmos
M1 net_0 in1 net_1 net_1 nmos
M2 outfirststage in2 net_1 net_1 nmos
M3 net_0 net_2 source_pmos source_pmos pmos
M4 net_2 net_2 source_pmos source_pmos pmos
M5 outfirststage net_0 net_2 net_2 pmos
M6 net_1 ibias source_nmos source_nmos nmos
M7 net_4 net_4 source_pmos source_pmos pmos
M8 out net_5 net_4 net_4 pmos
M9 out outfirststage source_nmos source_nmos nmos
M10 ibias ibias source_nmos source_nmos nmos
M11 net_5 net_5 bias_p_2m bias_p_2m pmos
M12 bias_p_2m net_4 source_pmos source_pmos pmos
M13 net_5 ibias source_nmos source_nmos nmos
Cap_load_1 out source_nmos
Cap_compensation_1 outfirststage out
.end two_stage_single_output_op_amp101
