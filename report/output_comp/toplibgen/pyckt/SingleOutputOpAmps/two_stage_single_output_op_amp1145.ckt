.suckt  two_stage_single_output_op_amp1145 ibias in1 in2 out source_nmos source_pmos
M1 net_0 in1 net_1 net_1 nmos
M2 net_2 in2 net_1 net_1 nmos
M3 net_3 net_4 net_0 net_0 nmos
M4 outfirststage net_4 net_2 net_2 nmos
M5 net_5 net_3 source_pmos source_pmos pmos
M6 net_3 bias_p_3 net_5 net_5 pmos
M7 net_7 net_3 source_pmos source_pmos pmos
M8 outfirststage bias_p_3 net_7 net_7 pmos
M9 net_1 ibias source_nmos source_nmos nmos
M10 net_9 net_9 source_pmos source_pmos pmos
M11 out net_10 net_9 net_9 pmos
M12 out outfirststage source_nmos source_nmos nmos
M13 net_4 net_4 net_1 net_1 nmos
M14 ibias ibias source_nmos source_nmos nmos
M15 net_10 net_10 bias_p_2m bias_p_2m pmos
M16 bias_p_2m net_9 source_pmos source_pmos pmos
M17 bias_p_3 bias_p_3 source_pmos source_pmos pmos
M18 bias_p_4 bias_p_4 source_pmos source_pmos pmos
M19 net_10 ibias source_nmos source_nmos nmos
M20 net_4 bias_p_4 source_pmos source_pmos pmos
M21 bias_p_3 ibias source_nmos source_nmos nmos
M22 bias_p_4 ibias source_nmos source_nmos nmos
Cap_load_1 out source_nmos
Cap_compensation_1 outfirststage out
.end two_stage_single_output_op_amp1145
