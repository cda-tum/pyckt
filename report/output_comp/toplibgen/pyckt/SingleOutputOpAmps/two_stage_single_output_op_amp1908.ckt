.suckt  two_stage_single_output_op_amp1908 ibias in1 in2 out source_nmos source_pmos
M1 net_0 in1 net_1 net_1 pmos
M2 outfirststage in2 net_1 net_1 pmos
M3 net_0 net_2 source_pmos source_pmos pmos
M4 net_2 net_2 source_pmos source_pmos pmos
M5 outfirststage net_0 net_2 net_2 pmos
M6 net_0 bias_n_2 source_nmos source_nmos nmos
M7 outfirststage bias_n_2 source_nmos source_nmos nmos
M8 net_4 ibias source_pmos source_pmos pmos
M9 net_1 bias_p_3 net_4 net_4 pmos
M10 net_7 outfirststage source_pmos source_pmos pmos
M11 out bias_p_3 net_7 net_7 pmos
M12 net_9 net_9 source_nmos source_nmos nmos
M13 out net_10 net_9 net_9 nmos
M14 net_10 net_10 bias_n_1m bias_n_1m nmos
M15 bias_n_1m net_9 source_nmos source_nmos nmos
M16 bias_n_2 bias_n_2 source_nmos source_nmos nmos
M17 bias_p_3 bias_p_3 source_pmos source_pmos pmos
M18 ibias ibias source_pmos source_pmos pmos
M19 bias_n_2 ibias source_pmos source_pmos pmos
M20 bias_p_3 bias_n_2 source_nmos source_nmos nmos
M21 net_10 ibias source_pmos source_pmos pmos
Cap_load_1 out source_nmos
Cap_compensation_1 outfirststage out
.end two_stage_single_output_op_amp1908
