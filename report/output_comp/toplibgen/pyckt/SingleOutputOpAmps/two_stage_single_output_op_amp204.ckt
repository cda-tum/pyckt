.suckt  two_stage_single_output_op_amp204 ibias in1 in2 out source_nmos source_pmos
M1 net_0 in1 net_1 net_1 pmos
M2 outfirststage in2 net_1 net_1 pmos
M3 net_0 net_2 source_nmos source_nmos nmos
M4 net_2 net_2 source_nmos source_nmos nmos
M5 outfirststage net_0 net_2 net_2 nmos
M6 net_3 bias_p_3 source_pmos source_pmos pmos
M7 net_1 bias_p_2 net_3 net_3 pmos
M8 net_6 outfirststage source_pmos source_pmos pmos
M9 out bias_p_2 net_6 net_6 pmos
M10 net_8 net_8 source_nmos source_nmos nmos
M11 out ibias net_8 net_8 nmos
M12 ibias ibias bias_n_1m bias_n_1m nmos
M13 bias_n_1m net_8 source_nmos source_nmos nmos
M14 bias_p_2 bias_p_2 source_pmos source_pmos pmos
M15 bias_p_3 bias_p_3 source_pmos source_pmos pmos
M16 bias_p_3 net_8 source_nmos source_nmos nmos
M17 bias_p_2 net_8 source_nmos source_nmos nmos
Cap_load_1 out source_nmos
Cap_compensation_1 outfirststage out
.end two_stage_single_output_op_amp204
