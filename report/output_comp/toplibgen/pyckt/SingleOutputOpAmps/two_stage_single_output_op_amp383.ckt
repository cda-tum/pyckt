.suckt  two_stage_single_output_op_amp383 ibias in1 in2 out source_nmos source_pmos
M1 net_0 in1 net_1 net_1 nmos
M2 outfirststage in2 net_1 net_1 nmos
M3 net_0 net_2 source_pmos source_pmos pmos
M4 net_2 net_2 source_pmos source_pmos pmos
M5 outfirststage net_0 net_2 net_2 pmos
M6 net_3 net_3 source_nmos source_nmos nmos
M7 net_1 net_4 net_3 net_3 nmos
M8 net_5 outfirststage source_pmos source_pmos pmos
M9 out bias_p_3 net_5 net_5 pmos
M10 net_7 bias_n_2b source_nmos source_nmos nmos
M11 out ibias net_7 net_7 nmos
M12 net_4 net_4 bias_n_1m bias_n_1m nmos
M13 bias_n_1m net_3 source_nmos source_nmos nmos
M14 bias_n_2b bias_n_2b source_nmos source_nmos nmos
M15 ibias ibias bias_n_2b bias_n_2b nmos
M16 bias_p_3 bias_p_3 source_pmos source_pmos pmos
M17 bias_p_4 bias_p_4 source_pmos source_pmos pmos
M18 bias_p_3 bias_n_2b source_nmos source_nmos nmos
M19 net_4 bias_p_4 source_pmos source_pmos pmos
M20 bias_p_4 bias_n_2b source_nmos source_nmos nmos
Cap_load_1 out source_nmos
Cap_compensation_1 outfirststage out
.end two_stage_single_output_op_amp383
