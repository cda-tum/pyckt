.suckt  symmetrical_op_amp120 ibias in1 in2 out source_nmos source_pmos
M1 out2fs in1 net_0 net_0 nmos
M2 inoutputtc in2 net_0 net_0 nmos
M3 net_1 out2fs source_pmos source_pmos pmos
M4 out2fs out2fs net_1 net_1 pmos
M5 net_2 inoutputtc source_pmos source_pmos pmos
M6 inoutputtc inoutputtc net_2 net_2 pmos
M7 net_0 ibias source_nmos source_nmos nmos
M8 net_4 out2fs source_pmos source_pmos pmos
M9 out out2fs net_4 net_4 pmos
M10 out instagebias source_nmos source_nmos nmos
M11 net_5 inoutputtc source_pmos source_pmos pmos
M12 instagebias inoutputtc net_5 net_5 pmos
M13 instagebias instagebias source_nmos source_nmos nmos
M14 ibias ibias source_nmos source_nmos nmos
Cap_load_1 out source_nmos
.end symmetrical_op_amp120
