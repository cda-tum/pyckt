.suckt  two_stage_single_output_op_amp18 ibias in1 in2 out source_nmos source_pmos
M1 net_0 in1 net_1 net_1 pmos
M2 outfirststage in2 net_1 net_1 pmos
M3 net_0 net_2 source_nmos source_nmos nmos
M4 net_2 net_2 source_nmos source_nmos nmos
M5 outfirststage net_0 net_2 net_2 nmos
M6 net_1 ibias source_pmos source_pmos pmos
M7 net_4 net_4 source_pmos source_pmos pmos
M8 out net_5 net_4 net_4 pmos
M9 net_6 outfirststage source_nmos source_nmos nmos
M10 out bias_n_1 net_6 net_6 nmos
M11 bias_n_1 bias_n_1 source_nmos source_nmos nmos
M12 net_5 net_5 bias_p_2m bias_p_2m pmos
M13 bias_p_2m net_4 source_pmos source_pmos pmos
M14 ibias ibias source_pmos source_pmos pmos
M15 bias_n_4 bias_n_4 source_nmos source_nmos nmos
M16 bias_n_1 ibias source_pmos source_pmos pmos
M17 net_5 bias_n_4 source_nmos source_nmos nmos
M18 bias_n_4 ibias source_pmos source_pmos pmos
Cap_load_1 out source_nmos
Cap_compensation_1 outfirststage out
.end two_stage_single_output_op_amp18
