.suckt  symmetrical_op_amp112 ibias in1 in2 out source_nmos source_pmos
M1 out2fs in1 net_0 net_0 nmos
M2 inoutputtc in2 net_0 net_0 nmos
M3 out1fs out1fs source_pmos source_pmos pmos
M4 out2fs out2fs out1fs out1fs pmos
M5 insourcetc insourcetc source_pmos source_pmos pmos
M6 inoutputtc inoutputtc insourcetc insourcetc pmos
M7 net_0 ibias source_nmos source_nmos nmos
M8 net_2 out1fs source_pmos source_pmos pmos
M9 out out2fs net_2 net_2 pmos
M10 insourcestagebias insourcestagebias source_nmos source_nmos nmos
M11 out inoutputstagebias insourcestagebias insourcestagebias nmos
M12 net_3 insourcetc source_pmos source_pmos pmos
M13 inoutputstagebias inoutputtc net_3 net_3 pmos
M14 net_4 insourcestagebias source_nmos source_nmos nmos
M15 inoutputstagebias inoutputstagebias net_4 net_4 nmos
M16 ibias ibias source_nmos source_nmos nmos
Cap_load_1 out source_nmos
.end symmetrical_op_amp112
