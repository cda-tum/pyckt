.suckt  two_stage_single_output_op_amp1343 ibias in1 in2 out source_nmos source_pmos
M1 net_0 in1 net_1 net_1 pmos
M2 net_2 in2 net_1 net_1 pmos
M3 net_3 net_4 net_0 net_0 pmos
M4 outfirststage net_4 net_2 net_2 pmos
M5 net_5 net_3 source_nmos source_nmos nmos
M6 net_3 net_3 net_5 net_5 nmos
M7 net_6 net_3 source_nmos source_nmos nmos
M8 outfirststage net_3 net_6 net_6 nmos
M9 net_7 net_7 source_pmos source_pmos pmos
M10 net_1 net_8 net_7 net_7 pmos
M11 net_9 outfirststage source_pmos source_pmos pmos
M12 out bias_p_3 net_9 net_9 pmos
M13 net_11 bias_n_1b source_nmos source_nmos nmos
M14 out ibias net_11 net_11 nmos
M15 bias_n_1b bias_n_1b source_nmos source_nmos nmos
M16 ibias ibias bias_n_1b bias_n_1b nmos
M17 net_4 net_4 net_1 net_1 pmos
M18 net_8 net_8 bias_p_2m bias_p_2m pmos
M19 bias_p_2m net_7 source_pmos source_pmos pmos
M20 bias_p_3 bias_p_3 source_pmos source_pmos pmos
M21 net_8 bias_n_1b source_nmos source_nmos nmos
M22 net_4 bias_n_1b source_nmos source_nmos nmos
M23 bias_p_3 bias_n_1b source_nmos source_nmos nmos
Cap_load_1 out source_nmos
Cap_compensation_1 outfirststage out
.end two_stage_single_output_op_amp1343
