.suckt  two_stage_single_output_op_amp1405 ibias in1 in2 out source_nmos source_pmos
M1 net_0 in1 net_1 net_1 nmos
M2 net_2 in2 net_1 net_1 nmos
M3 net_3 net_4 net_0 net_0 nmos
M4 outfirststage net_4 net_2 net_2 nmos
M5 net_3 net_3 source_pmos source_pmos pmos
M6 net_5 net_3 source_pmos source_pmos pmos
M7 outfirststage bias_p_2 net_5 net_5 pmos
M8 net_7 net_7 source_nmos source_nmos nmos
M9 net_1 ibias net_7 net_7 nmos
M10 out bias_p_3 source_pmos source_pmos pmos
M11 out outfirststage source_nmos source_nmos nmos
M12 net_4 net_4 net_1 net_1 nmos
M13 ibias ibias bias_n_1m bias_n_1m nmos
M14 bias_n_1m net_7 source_nmos source_nmos nmos
M15 bias_p_2 bias_p_2 source_pmos source_pmos pmos
M16 bias_p_3 bias_p_3 source_pmos source_pmos pmos
M17 bias_p_3 net_7 source_nmos source_nmos nmos
M18 net_4 bias_p_3 source_pmos source_pmos pmos
M19 bias_p_2 net_7 source_nmos source_nmos nmos
Cap_load_1 out source_nmos
Cap_compensation_1 outfirststage out
.end two_stage_single_output_op_amp1405
