.suckt  symmetrical_op_amp163 ibias in1 in2 out source_nmos source_pmos
M1 out2fs in1 net_0 net_0 pmos
M2 inoutputtc in2 net_0 net_0 pmos
M3 net_1 out2fs source_nmos source_nmos nmos
M4 out2fs out2fs net_1 net_1 nmos
M5 net_2 inoutputtc source_nmos source_nmos nmos
M6 inoutputtc inoutputtc net_2 net_2 nmos
M7 net_3 net_3 source_pmos source_pmos pmos
M8 net_0 ibias net_3 net_3 pmos
M9 net_5 instagebias source_pmos source_pmos pmos
M10 out bias_p_2 net_5 net_5 pmos
M11 net_7 out2fs source_nmos source_nmos nmos
M12 out out2fs net_7 net_7 nmos
M13 net_8 inoutputtc source_nmos source_nmos nmos
M14 instagebias inoutputtc net_8 net_8 nmos
M15 instagebias instagebias source_pmos source_pmos pmos
M16 ibias ibias bias_p_1m bias_p_1m pmos
M17 bias_p_1m net_3 source_pmos source_pmos pmos
M18 bias_p_2 bias_p_2 source_pmos source_pmos pmos
M19 bias_n_3 bias_n_3 source_nmos source_nmos nmos
M20 bias_p_2 bias_n_3 source_nmos source_nmos nmos
M21 bias_n_3 net_3 source_pmos source_pmos pmos
Cap_load_1 out source_nmos
.end symmetrical_op_amp163
