.suckt  symmetrical_op_amp29 ibias in1 in2 out source_nmos source_pmos
M1 out1fs in1 net_0 net_0 pmos
M2 out2fs in2 net_0 net_0 pmos
M3 out1fs out1fs source_nmos source_nmos nmos
M4 out2fs out2fs source_nmos source_nmos nmos
M5 net_1 bias_p_1b source_pmos source_pmos pmos
M6 net_0 ibias net_1 net_1 pmos
M7 out instagebias source_pmos source_pmos pmos
M8 out out1fs source_nmos source_nmos nmos
M9 instagebias out2fs source_nmos source_nmos nmos
M10 instagebias instagebias source_pmos source_pmos pmos
M11 bias_p_1b bias_p_1b source_pmos source_pmos pmos
M12 ibias ibias bias_p_1b bias_p_1b pmos
Cap_load_1 out source_nmos
.end symmetrical_op_amp29
