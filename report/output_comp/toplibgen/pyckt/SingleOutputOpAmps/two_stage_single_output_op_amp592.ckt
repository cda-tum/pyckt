.suckt  two_stage_single_output_op_amp592 ibias in1 in2 out source_nmos source_pmos
M1 net_0 in1 net_1 net_1 nmos
M2 net_2 in2 net_1 net_1 nmos
M3 net_0 bias_p_3b source_pmos source_pmos pmos
M4 net_4 ibias net_0 net_0 pmos
M5 net_2 bias_p_3b source_pmos source_pmos pmos
M6 outfirststage ibias net_2 net_2 pmos
M7 net_4 net_4 source_nmos source_nmos nmos
M8 outfirststage net_4 source_nmos source_nmos nmos
M9 net_1 bias_n_2 source_nmos source_nmos nmos
M10 net_7 bias_p_3b source_pmos source_pmos pmos
M11 out ibias net_7 net_7 pmos
M12 net_10 outfirststage source_nmos source_nmos nmos
M13 out bias_n_1 net_10 net_10 nmos
M14 bias_n_1 bias_n_1 source_nmos source_nmos nmos
M15 bias_n_2 bias_n_2 source_nmos source_nmos nmos
M16 bias_p_3b bias_p_3b source_pmos source_pmos pmos
M17 ibias ibias bias_p_3b bias_p_3b pmos
M18 bias_n_2 bias_p_3b source_pmos source_pmos pmos
M19 bias_n_1 bias_p_3b source_pmos source_pmos pmos
Cap_load_1 out source_nmos
Cap_compensation_1 outfirststage out
.end two_stage_single_output_op_amp592
