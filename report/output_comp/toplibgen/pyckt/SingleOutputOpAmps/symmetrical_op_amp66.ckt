.suckt  symmetrical_op_amp66 ibias in1 in2 out source_nmos source_pmos
M1 out1fs in1 net_0 net_0 nmos
M2 out2fs in2 net_0 net_0 nmos
M3 out1fs out1fs source_pmos source_pmos pmos
M4 out2fs out2fs source_pmos source_pmos pmos
M5 net_1 bias_n_1b source_nmos source_nmos nmos
M6 net_0 ibias net_1 net_1 nmos
M7 net_4 out1fs source_pmos source_pmos pmos
M8 out bias_p_2 net_4 net_4 pmos
M9 net_5 insourcestagebias source_nmos source_nmos nmos
M10 out inoutputstagebias net_5 net_5 nmos
M11 net_6 out2fs source_pmos source_pmos pmos
M12 inoutputstagebias bias_p_2 net_6 net_6 pmos
M13 insourcestagebias insourcestagebias source_nmos source_nmos nmos
M14 inoutputstagebias inoutputstagebias insourcestagebias insourcestagebias nmos
M15 bias_n_1b bias_n_1b source_nmos source_nmos nmos
M16 ibias ibias bias_n_1b bias_n_1b nmos
M17 bias_p_2 bias_p_2 source_pmos source_pmos pmos
M18 bias_p_2 bias_n_1b source_nmos source_nmos nmos
Cap_load_1 out source_nmos
.end symmetrical_op_amp66
