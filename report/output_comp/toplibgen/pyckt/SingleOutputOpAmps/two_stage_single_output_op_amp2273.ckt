.suckt  two_stage_single_output_op_amp2273 ibias in1 in2 out source_nmos source_pmos
M1 net_0 in1 net_1 net_1 nmos
M2 outfirststage in2 net_1 net_1 nmos
M3 net_0 net_2 source_nmos source_nmos nmos
M4 net_2 net_2 source_nmos source_nmos nmos
M5 outfirststage net_0 net_2 net_2 nmos
M6 net_3 bias_p_3b source_pmos source_pmos pmos
M7 net_0 bias_p_3t net_3 net_3 pmos
M8 net_6 bias_p_3b source_pmos source_pmos pmos
M9 outfirststage bias_p_3t net_6 net_6 pmos
M10 net_7 net_7 source_nmos source_nmos nmos
M11 net_1 ibias net_7 net_7 nmos
M12 net_9 net_9 source_pmos source_pmos pmos
M13 out net_10 net_9 net_9 pmos
M14 out outfirststage source_nmos source_nmos nmos
M15 ibias ibias bias_n_1m bias_n_1m nmos
M16 bias_n_1m net_7 source_nmos source_nmos nmos
M17 net_10 net_10 bias_p_2m bias_p_2m pmos
M18 bias_p_2m net_9 source_pmos source_pmos pmos
M19 bias_p_3b bias_p_3b source_pmos source_pmos pmos
M20 bias_p_3t bias_p_3t bias_p_3b bias_p_3b pmos
M21 bias_p_3t net_7 source_nmos source_nmos nmos
M22 net_10 net_7 source_nmos source_nmos nmos
Cap_load_1 out source_nmos
Cap_compensation_1 outfirststage out
.end two_stage_single_output_op_amp2273
