.suckt  two_stage_single_output_op_amp2293 ibias in1 in2 out source_nmos source_pmos
M1 net_0 in1 net_1 net_1 nmos
M2 outfirststage in2 net_1 net_1 nmos
M3 net_0 net_0 source_nmos source_nmos nmos
M4 net_2 net_0 source_nmos source_nmos nmos
M5 outfirststage bias_n_2 net_2 net_2 nmos
M6 net_0 ibias source_pmos source_pmos pmos
M7 outfirststage ibias source_pmos source_pmos pmos
M8 net_5 net_5 source_nmos source_nmos nmos
M9 net_1 net_6 net_5 net_5 nmos
M10 out ibias source_pmos source_pmos pmos
M11 out outfirststage source_nmos source_nmos nmos
M12 net_6 net_6 bias_n_1m bias_n_1m nmos
M13 bias_n_1m net_5 source_nmos source_nmos nmos
M14 bias_n_2 bias_n_2 source_nmos source_nmos nmos
M15 ibias ibias source_pmos source_pmos pmos
M16 net_6 ibias source_pmos source_pmos pmos
M17 bias_n_2 ibias source_pmos source_pmos pmos
Cap_load_1 out source_nmos
Cap_compensation_1 outfirststage out
.end two_stage_single_output_op_amp2293
