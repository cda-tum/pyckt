.suckt  one_stage_single_output_op_amp158 ibias in1 in2 out source_nmos source_pmos
M1 net_0 in1 net_1 net_1 pmos
M2 out in2 net_1 net_1 pmos
M3 net_0 net_0 source_pmos source_pmos pmos
M4 out net_0 source_pmos source_pmos pmos
M5 net_2 bias_n_1b source_nmos source_nmos nmos
M6 net_0 bias_n_1t net_2 net_2 nmos
M7 net_5 bias_n_1b source_nmos source_nmos nmos
M8 out bias_n_1t net_5 net_5 nmos
M9 net_6 net_6 source_pmos source_pmos pmos
M10 net_1 ibias net_6 net_6 pmos
M11 bias_n_1b bias_n_1b source_nmos source_nmos nmos
M12 bias_n_1t bias_n_1t bias_n_1b bias_n_1b nmos
M13 ibias ibias bias_p_2m bias_p_2m pmos
M14 bias_p_2m net_6 source_pmos source_pmos pmos
M15 bias_n_1t net_6 source_pmos source_pmos pmos
Cap_load_1 out source_nmos
.end one_stage_single_output_op_amp158
