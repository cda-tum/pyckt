.suckt  one_stage_single_output_op_amp3 ibias in1 in2 out source_nmos source_pmos
M1 net_0 in1 net_1 net_1 pmos
M2 out in2 net_1 net_1 pmos
M3 net_0 net_0 source_nmos source_nmos nmos
M4 net_2 net_0 source_nmos source_nmos nmos
M5 out bias_n_1 net_2 net_2 nmos
M6 net_1 ibias source_pmos source_pmos pmos
M7 bias_n_1 bias_n_1 source_nmos source_nmos nmos
M8 ibias ibias source_pmos source_pmos pmos
M9 bias_n_1 ibias source_pmos source_pmos pmos
Cap_load_1 out source_nmos
.end one_stage_single_output_op_amp3
