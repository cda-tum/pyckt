.suckt  2stage_nmos_input ibias in1 in2 out source_nmos source_pmos
M1 net_0 in1 net_1 net_1 nmos W=34e-6 L=1e-6
M2 outfirststage in2 net_1 net_1 nmos W=34e-6 L=1e-6
M3 net_0 net_0 source_nmos source_nmos nmos W=1e-6 L=1e-6
M4 outfirststage net_0 source_nmos source_nmos nmos W=1e-6 L=1e-6
M5 net_2 bias_p_4 source_pmos source_pmos pmos W=2e-6 L=1e-6
M6 net_0 bias_p_3 net_2 net_2 pmos W=1e-6 L=1e-6
M7 net_5 bias_p_4 source_pmos source_pmos pmos W=2e-6 L=1e-6
M8 outfirststage bias_p_3 net_5 net_5 pmos W=1e-6 L=1e-6
M9 net_6 ibias source_nmos source_nmos nmos W=1e-6 L=1e-6
M10 net_1 bias_n_1 net_6 net_6 nmos W=1e-6 L=1e-6
M11 out bias_p_4 source_pmos source_pmos pmos W=2e-6 L=1e-6
M12 net_10 outfirststage source_nmos source_nmos nmos W=2e-6 L=1e-6
M13 out bias_n_1 net_10 net_10 nmos W=90e-6 L=1e-6
M14 bias_n_1 bias_n_1 source_nmos source_nmos nmos W=1e-6 L=1e-6
M15 ibias ibias source_nmos source_nmos nmos W=1e-6 L=1e-6
M16 bias_p_3 bias_p_3 source_pmos source_pmos pmos W=1e-6 L=15e-6
M17 bias_p_4 bias_p_4 source_pmos source_pmos pmos W=2e-6 L=1e-6
M18 bias_p_4 ibias source_nmos source_nmos nmos W=1e-6 L=1e-6
M19 bias_n_1 bias_p_4 source_pmos source_pmos pmos W=2e-6 L=1e-6
M20 bias_p_3 ibias source_nmos source_nmos nmos W=1e-6 L=1e-6
Cap_load_1 out source_nmos
Cap_compensation_1 outfirststage out
.end 2stage_nmos_input
