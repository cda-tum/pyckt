.suckt  symmetrical_op_amp_4152 ibias in1 in2 out source_nmos source_pmos
M1 out1fs in1 net_0 net_0 nmos W=981e-6 L=1e-6
M2 out2fs in2 net_0 net_0 nmos W=981e-6 L=1e-6
M3 out1fs out1fs source_pmos source_pmos pmos W=6e-6 L=1e-6
M4 out2fs out2fs source_pmos source_pmos pmos W=1e-6 L=1e-6
M5 net_1 ibias source_nmos source_nmos nmos W=1e-6 L=1e-6
M6 net_0 bias_n_1 net_1 net_1 nmos W=1e-6 L=1e-6
M7 out out1fs source_pmos source_pmos pmos W=6e-6 L=1e-6
M8 net_4 insourcestagebias source_nmos source_nmos nmos W=33e-6 L=1e-6
M9 out bias_n_1 net_4 net_4 nmos W=33e-6 L=1e-6
M10 insourcestagebias out2fs source_pmos source_pmos pmos W=1e-6 L=1e-6
M11 net_5 insourcestagebias source_nmos source_nmos nmos W=33e-6 L=1e-6
M12 insourcestagebias bias_n_1 net_5 net_5 nmos W=33e-6 L=1e-6
M13 bias_n_1 bias_n_1 source_nmos source_nmos nmos W=1e-6 L=1e-6
M14 ibias ibias source_nmos source_nmos nmos W=1e-6 L=1e-6
M15 bias_p_3 bias_p_3 source_pmos source_pmos pmos W=1e-6 L=1e-6
M16 bias_n_1 bias_p_3 source_pmos source_pmos pmos W=1e-6 L=1e-6
M17 bias_p_3 ibias source_nmos source_nmos nmos W=1e-6 L=1e-6
Cap_load_1 out source_nmos
.end symmetrical_op_amp_4152
