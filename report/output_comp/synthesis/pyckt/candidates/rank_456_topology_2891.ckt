.suckt  2stage_nmos_input ibias in1 in2 out source_nmos source_pmos
M1 net_0 in1 net_1 net_1 nmos W=34e-6 L=1e-6
M2 outfirststage in2 net_1 net_1 nmos W=34e-6 L=1e-6
M3 net_0 net_0 source_nmos source_nmos nmos W=1e-6 L=1e-6
M4 net_2 net_0 source_nmos source_nmos nmos W=1e-6 L=1e-6
M5 outfirststage bias_n_1 net_2 net_2 nmos W=1e-6 L=1e-6
M6 net_4 bias_p_3b source_pmos source_pmos pmos W=1e-6 L=1e-6
M7 net_0 ibias net_4 net_4 pmos W=1e-6 L=1e-6
M8 net_7 bias_p_3b source_pmos source_pmos pmos W=1e-6 L=1e-6
M9 outfirststage ibias net_7 net_7 pmos W=1e-6 L=1e-6
M10 net_8 bias_n_2 source_nmos source_nmos nmos W=1e-6 L=1e-6
M11 net_1 bias_n_1 net_8 net_8 nmos W=1e-6 L=1e-6
M12 net_11 bias_p_3b source_pmos source_pmos pmos W=1e-6 L=1e-6
M13 out ibias net_11 net_11 pmos W=1e-6 L=1e-6
M14 net_14 outfirststage source_nmos source_nmos nmos W=1e-6 L=1e-6
M15 out bias_n_1 net_14 net_14 nmos W=94e-6 L=1e-6
M16 bias_n_1 bias_n_1 source_nmos source_nmos nmos W=1e-6 L=1e-6
M17 bias_n_2 bias_n_2 source_nmos source_nmos nmos W=1e-6 L=1e-6
M18 bias_p_3b bias_p_3b source_pmos source_pmos pmos W=1e-6 L=1e-6
M19 ibias ibias bias_p_3b bias_p_3b pmos W=1e-6 L=1e-6
M20 bias_n_2 bias_p_3b source_pmos source_pmos pmos W=1e-6 L=1e-6
M21 bias_n_1 bias_p_3b source_pmos source_pmos pmos W=1e-6 L=1e-6
Cap_load_1 out source_nmos
Cap_compensation_1 outfirststage out
.end 2stage_nmos_input
