.suckt  2stage_pmos_input ibias in1 in2 out source_nmos source_pmos
M1 net_0 in1 net_1 net_1 pmos W=101e-6 L=1e-6
M2 net_2 in2 net_1 net_1 pmos W=101e-6 L=1e-6
M3 net_3 net_4 net_0 net_0 pmos W=101e-6 L=1e-6
M4 outfirststage net_4 net_2 net_2 pmos W=101e-6 L=1e-6
M5 net_3 net_3 source_nmos source_nmos nmos W=1e-6 L=1e-6
M6 outfirststage net_3 source_nmos source_nmos nmos W=1e-6 L=1e-6
M7 net_5 bias_p_3 source_pmos source_pmos pmos W=1e-6 L=1e-6
M8 net_1 bias_p_2 net_5 net_5 pmos W=2e-6 L=1e-6
M9 net_8 outfirststage source_pmos source_pmos pmos W=1e-6 L=1e-6
M10 out bias_p_2 net_8 net_8 pmos W=83e-6 L=1e-6
M11 net_10 net_10 source_nmos source_nmos nmos W=2e-6 L=1e-6
M12 out ibias net_10 net_10 nmos W=2e-6 L=1e-6
M13 ibias ibias bias_n_1m bias_n_1m nmos W=2e-6 L=1e-6
M14 bias_n_1m net_10 source_nmos source_nmos nmos W=2e-6 L=1e-6
M15 net_4 net_4 net_1 net_1 pmos W=1e-6 L=1e-6
M16 bias_p_2 bias_p_2 source_pmos source_pmos pmos W=1e-6 L=16e-6
M17 bias_p_3 bias_p_3 source_pmos source_pmos pmos W=1e-6 L=1e-6
M18 bias_p_3 net_10 source_nmos source_nmos nmos W=2e-6 L=1e-6
M19 net_4 net_10 source_nmos source_nmos nmos W=2e-6 L=1e-6
M20 bias_p_2 net_10 source_nmos source_nmos nmos W=2e-6 L=1e-6
Cap_load_1 out source_nmos
Cap_compensation_1 outfirststage out
.end 2stage_pmos_input
