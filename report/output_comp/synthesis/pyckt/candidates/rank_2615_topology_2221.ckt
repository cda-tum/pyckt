.suckt  2stage_nmos_input ibias in1 in2 out source_nmos source_pmos
M1 net_0 in1 net_1 net_1 nmos W=10e-6 L=1e-6
M2 outfirststage in2 net_1 net_1 nmos W=10e-6 L=1e-6
M3 net_2 net_0 source_nmos source_nmos nmos W=1e-6 L=1e-6
M4 net_0 bias_n_1 net_2 net_2 nmos W=1e-6 L=1e-6
M5 net_4 net_0 source_nmos source_nmos nmos W=1e-6 L=1e-6
M6 outfirststage bias_n_1 net_4 net_4 nmos W=1e-6 L=1e-6
M7 net_0 bias_p_4 source_pmos source_pmos pmos W=1e-6 L=1e-6
M8 outfirststage bias_p_4 source_pmos source_pmos pmos W=1e-6 L=1e-6
M9 net_1 ibias source_nmos source_nmos nmos W=1e-6 L=1e-6
M10 net_7 outfirststage source_pmos source_pmos pmos W=1e-6 L=1e-6
M11 out bias_p_3 net_7 net_7 pmos W=5e-6 L=1e-6
M12 out ibias source_nmos source_nmos nmos W=1e-6 L=1e-6
M13 bias_n_1 bias_n_1 source_nmos source_nmos nmos W=1e-6 L=1e-6
M14 ibias ibias source_nmos source_nmos nmos W=1e-6 L=1e-6
M15 bias_p_3 bias_p_3 source_pmos source_pmos pmos W=1e-6 L=20e-6
M16 bias_p_4 bias_p_4 source_pmos source_pmos pmos W=1e-6 L=1e-6
M17 bias_p_4 ibias source_nmos source_nmos nmos W=1e-6 L=1e-6
M18 bias_n_1 bias_p_4 source_pmos source_pmos pmos W=1e-6 L=1e-6
M19 bias_p_3 ibias source_nmos source_nmos nmos W=1e-6 L=1e-6
Cap_load_1 out source_nmos
Cap_compensation_1 outfirststage out
.end 2stage_nmos_input
