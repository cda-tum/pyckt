.suckt  2stage_nmos_input ibias in1 in2 out source_nmos source_pmos
M1 net_0 in1 net_1 net_1 nmos W=24e-6 L=1e-6
M2 outfirststage in2 net_1 net_1 nmos W=24e-6 L=1e-6
M3 net_2 net_3 source_nmos source_nmos nmos W=1e-6 L=1e-6
M4 net_0 net_0 net_2 net_2 nmos W=1e-6 L=1e-6
M5 net_3 net_3 source_nmos source_nmos nmos W=1e-6 L=1e-6
M6 outfirststage net_0 net_3 net_3 nmos W=1e-6 L=1e-6
M7 net_4 bias_p_4b source_pmos source_pmos pmos W=1e-6 L=1e-6
M8 net_0 bias_p_4t net_4 net_4 pmos W=1e-6 L=1e-6
M9 net_7 bias_p_4b source_pmos source_pmos pmos W=1e-6 L=1e-6
M10 outfirststage bias_p_4t net_7 net_7 pmos W=1e-6 L=1e-6
M11 net_8 ibias source_nmos source_nmos nmos W=1e-6 L=1e-6
M12 net_1 bias_n_1 net_8 net_8 nmos W=1e-6 L=2e-6
M13 net_11 net_11 source_pmos source_pmos pmos W=7e-6 L=1e-6
M14 out net_12 net_11 net_11 pmos W=7e-6 L=1e-6
M15 net_13 outfirststage source_nmos source_nmos nmos W=1e-6 L=1e-6
M16 out bias_n_1 net_13 net_13 nmos W=20e-6 L=1e-6
M17 bias_n_1 bias_n_1 source_nmos source_nmos nmos W=1e-6 L=3e-6
M18 ibias ibias source_nmos source_nmos nmos W=1e-6 L=1e-6
M19 net_12 net_12 bias_p_3m bias_p_3m pmos W=7e-6 L=1e-6
M20 bias_p_3m net_11 source_pmos source_pmos pmos W=7e-6 L=1e-6
M21 bias_p_4b bias_p_4b source_pmos source_pmos pmos W=1e-6 L=1e-6
M22 bias_p_4t bias_p_4t bias_p_4b bias_p_4b pmos W=1e-6 L=1e-6
M23 bias_p_4t ibias source_nmos source_nmos nmos W=1e-6 L=1e-6
M24 bias_n_1 bias_p_4b source_pmos source_pmos pmos W=1e-6 L=1e-6
M25 net_12 ibias source_nmos source_nmos nmos W=1e-6 L=1e-6
Cap_load_1 out source_nmos
Cap_compensation_1 outfirststage out
.end 2stage_nmos_input
