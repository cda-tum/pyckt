.suckt  symmetrical_op_amp_4198 ibias in1 in2 out source_nmos source_pmos
M1 out2fs in1 net_0 net_0 nmos W=668e-6 L=1e-6
M2 inoutputtc in2 net_0 net_0 nmos W=668e-6 L=1e-6
M3 out1fs out1fs source_pmos source_pmos pmos W=7e-6 L=1e-6
M4 out2fs out2fs out1fs out1fs pmos W=7e-6 L=1e-6
M5 insourcetc insourcetc source_pmos source_pmos pmos W=1e-6 L=3e-6
M6 inoutputtc inoutputtc insourcetc insourcetc pmos W=1e-6 L=3e-6
M7 net_0 ibias source_nmos source_nmos nmos W=1e-6 L=1e-6
M8 net_2 out1fs source_pmos source_pmos pmos W=7e-6 L=1e-6
M9 out out2fs net_2 net_2 pmos W=7e-6 L=1e-6
M10 out instagebias source_nmos source_nmos nmos W=1e-6 L=1e-6
M11 net_3 insourcetc source_pmos source_pmos pmos W=1e-6 L=3e-6
M12 instagebias inoutputtc net_3 net_3 pmos W=1e-6 L=3e-6
M13 instagebias instagebias source_nmos source_nmos nmos W=1e-6 L=1e-6
M14 ibias ibias source_nmos source_nmos nmos W=1e-6 L=1e-6
Cap_load_1 out source_nmos
.end symmetrical_op_amp_4198
