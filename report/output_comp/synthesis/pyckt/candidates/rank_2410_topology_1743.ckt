.suckt  1stage_nmos_input ibias in1 in2 out source_nmos source_pmos
M1 net_0 in1 net_1 net_1 nmos W=7e-6 L=1e-6
M2 net_2 in2 net_1 net_1 nmos W=7e-6 L=1e-6
M3 net_3 net_4 net_0 net_0 nmos W=7e-6 L=1e-6
M4 out net_4 net_2 net_2 nmos W=7e-6 L=1e-6
M5 net_3 net_3 source_pmos source_pmos pmos W=1e-6 L=2e-6
M6 net_5 net_3 source_pmos source_pmos pmos W=1e-6 L=2e-6
M7 out bias_p_2 net_5 net_5 pmos W=13e-6 L=1e-6
M8 net_7 bias_n_1b source_nmos source_nmos nmos W=1e-6 L=1e-6
M9 net_1 ibias net_7 net_7 nmos W=1e-6 L=1e-6
M10 net_4 net_4 net_1 net_1 nmos W=1e-6 L=1e-6
M11 bias_n_1b bias_n_1b source_nmos source_nmos nmos W=1e-6 L=1e-6
M12 ibias ibias bias_n_1b bias_n_1b nmos W=1e-6 L=1e-6
M13 bias_p_2 bias_p_2 source_pmos source_pmos pmos W=1e-6 L=19e-6
M14 bias_p_3 bias_p_3 source_pmos source_pmos pmos W=1e-6 L=2e-6
M15 net_4 bias_p_3 source_pmos source_pmos pmos W=1e-6 L=2e-6
M16 bias_p_2 bias_n_1b source_nmos source_nmos nmos W=1e-6 L=1e-6
M17 bias_p_3 bias_n_1b source_nmos source_nmos nmos W=1e-6 L=1e-6
Cap_load_1 out source_nmos
.end 1stage_nmos_input
