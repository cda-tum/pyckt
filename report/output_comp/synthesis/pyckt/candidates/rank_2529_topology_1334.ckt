.suckt  2stage_pmos_input ibias in1 in2 out source_nmos source_pmos
M1 net_0 in1 net_1 net_1 pmos W=21e-6 L=1e-6
M2 net_2 in2 net_1 net_1 pmos W=21e-6 L=1e-6
M3 net_3 net_4 net_0 net_0 pmos W=21e-6 L=1e-6
M4 outfirststage net_4 net_2 net_2 pmos W=21e-6 L=1e-6
M5 net_5 net_6 source_nmos source_nmos nmos W=1e-6 L=1e-6
M6 net_3 net_3 net_5 net_5 nmos W=1e-6 L=1e-6
M7 net_6 net_6 source_nmos source_nmos nmos W=1e-6 L=1e-6
M8 outfirststage net_3 net_6 net_6 nmos W=1e-6 L=1e-6
M9 net_1 bias_p_2 source_pmos source_pmos pmos W=1e-6 L=1e-6
M10 out outfirststage source_pmos source_pmos pmos W=1e-6 L=2e-6
M11 out ibias source_nmos source_nmos nmos W=2e-6 L=1e-6
M12 ibias ibias source_nmos source_nmos nmos W=2e-6 L=1e-6
M13 net_4 net_4 net_1 net_1 pmos W=1e-6 L=1e-6
M14 bias_p_2 bias_p_2 source_pmos source_pmos pmos W=1e-6 L=1e-6
M15 bias_p_2 ibias source_nmos source_nmos nmos W=2e-6 L=1e-6
M16 net_4 ibias source_nmos source_nmos nmos W=2e-6 L=1e-6
Cap_load_1 out source_nmos
Cap_compensation_1 outfirststage out
.end 2stage_pmos_input
