.suckt  symmetrical_op_amp_4097 ibias in1 in2 out source_nmos source_pmos
M1 out1fs in1 net_0 net_0 pmos W=999e-6 L=1e-6
M2 out2fs in2 net_0 net_0 pmos W=999e-6 L=1e-6
M3 out1fs out1fs source_nmos source_nmos nmos W=2e-6 L=1e-6
M4 out2fs out2fs source_nmos source_nmos nmos W=1e-6 L=1e-6
M5 net_0 ibias source_pmos source_pmos pmos W=1e-6 L=1e-6
M6 net_2 insourcestagebias source_pmos source_pmos pmos W=80e-6 L=1e-6
M7 out bias_p_1 net_2 net_2 pmos W=80e-6 L=1e-6
M8 out out1fs source_nmos source_nmos nmos W=2e-6 L=1e-6
M9 insourcestagebias out2fs source_nmos source_nmos nmos W=1e-6 L=1e-6
M10 net_3 insourcestagebias source_pmos source_pmos pmos W=80e-6 L=1e-6
M11 insourcestagebias bias_p_1 net_3 net_3 pmos W=80e-6 L=1e-6
M12 bias_p_1 bias_p_1 source_pmos source_pmos pmos W=1e-6 L=11e-6
M13 ibias ibias source_pmos source_pmos pmos W=1e-6 L=1e-6
M14 bias_n_3 bias_n_3 source_nmos source_nmos nmos W=1e-6 L=1e-6
M15 bias_p_1 bias_n_3 source_nmos source_nmos nmos W=1e-6 L=1e-6
M16 bias_n_3 ibias source_pmos source_pmos pmos W=1e-6 L=1e-6
Cap_load_1 out source_nmos
.end symmetrical_op_amp_4097
