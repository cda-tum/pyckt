.suckt  symmetrical_op_amp_4204 ibias in1 in2 out source_nmos source_pmos
M1 out2fs in1 net_0 net_0 nmos W=4e-6 L=1e-6
M2 inoutputtc in2 net_0 net_0 nmos W=4e-6 L=1e-6
M3 out1fs out1fs source_pmos source_pmos pmos W=1e-6 L=1e-6
M4 out2fs out2fs out1fs out1fs pmos W=1e-6 L=1e-6
M5 insourcetc insourcetc source_pmos source_pmos pmos W=1e-6 L=1e-6
M6 inoutputtc inoutputtc insourcetc insourcetc pmos W=1e-6 L=1e-6
M7 net_0 ibias source_nmos source_nmos nmos W=1e-6 L=1e-6
M8 net_2 out1fs source_pmos source_pmos pmos W=1e-6 L=1e-6
M9 out out2fs net_2 net_2 pmos W=1e-6 L=1e-6
M10 insourcestagebias insourcestagebias source_nmos source_nmos nmos W=2e-6 L=1e-6
M11 out inoutputstagebias insourcestagebias insourcestagebias nmos W=2e-6 L=1e-6
M12 net_3 insourcetc source_pmos source_pmos pmos W=1e-6 L=1e-6
M13 inoutputstagebias inoutputtc net_3 net_3 pmos W=1e-6 L=1e-6
M14 net_4 insourcestagebias source_nmos source_nmos nmos W=2e-6 L=1e-6
M15 inoutputstagebias inoutputstagebias net_4 net_4 nmos W=2e-6 L=1e-6
M16 ibias ibias source_nmos source_nmos nmos W=1e-6 L=1e-6
Cap_load_1 out source_nmos
.end symmetrical_op_amp_4204
