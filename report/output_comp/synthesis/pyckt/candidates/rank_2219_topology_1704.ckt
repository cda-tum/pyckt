.suckt  1stage_nmos_input ibias in1 in2 out source_nmos source_pmos
M1 net_0 in1 net_1 net_1 nmos W=1000e-6 L=1e-6
M2 net_2 in2 net_1 net_1 nmos W=1000e-6 L=1e-6
M3 net_3 net_4 net_0 net_0 nmos W=1000e-6 L=1e-6
M4 out net_4 net_2 net_2 nmos W=1000e-6 L=1e-6
M5 net_3 net_3 source_pmos source_pmos pmos W=2e-6 L=1e-6
M6 out net_3 source_pmos source_pmos pmos W=2e-6 L=1e-6
M7 net_5 net_5 source_nmos source_nmos nmos W=1e-6 L=1e-6
M8 net_1 ibias net_5 net_5 nmos W=1e-6 L=1e-6
M9 net_4 net_4 net_1 net_1 nmos W=1e-6 L=1e-6
M10 ibias ibias bias_n_1m bias_n_1m nmos W=1e-6 L=1e-6
M11 bias_n_1m net_5 source_nmos source_nmos nmos W=1e-6 L=1e-6
M12 bias_p_2 bias_p_2 source_pmos source_pmos pmos W=1e-6 L=1e-6
M13 net_4 bias_p_2 source_pmos source_pmos pmos W=1e-6 L=1e-6
M14 bias_p_2 net_5 source_nmos source_nmos nmos W=1e-6 L=1e-6
Cap_load_1 out source_nmos
.end 1stage_nmos_input
