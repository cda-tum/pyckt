.suckt  2stage_pmos_input ibias in1 in2 out source_nmos source_pmos
M1 net_0 in1 net_1 net_1 pmos W=23e-6 L=1e-6
M2 outfirststage in2 net_1 net_1 pmos W=23e-6 L=1e-6
M3 net_0 net_2 source_pmos source_pmos pmos W=1e-6 L=1e-6
M4 net_2 net_2 source_pmos source_pmos pmos W=1e-6 L=1e-6
M5 outfirststage net_0 net_2 net_2 pmos W=1e-6 L=1e-6
M6 net_3 bias_n_1b source_nmos source_nmos nmos W=1e-6 L=1e-6
M7 net_0 bias_n_1t net_3 net_3 nmos W=1e-6 L=1e-6
M8 net_6 bias_n_1b source_nmos source_nmos nmos W=1e-6 L=1e-6
M9 outfirststage bias_n_1t net_6 net_6 nmos W=1e-6 L=1e-6
M10 net_1 ibias source_pmos source_pmos pmos W=4e-6 L=1e-6
M11 out ibias source_pmos source_pmos pmos W=4e-6 L=1e-6
M12 out outfirststage source_nmos source_nmos nmos W=2e-6 L=1e-6
M13 bias_n_1b bias_n_1b source_nmos source_nmos nmos W=1e-6 L=1e-6
M14 bias_n_1t bias_n_1t bias_n_1b bias_n_1b nmos W=1e-6 L=1e-6
M15 ibias ibias source_pmos source_pmos pmos W=4e-6 L=1e-6
M16 bias_n_1t ibias source_pmos source_pmos pmos W=4e-6 L=1e-6
Cap_load_1 out source_nmos
Cap_compensation_1 outfirststage out
.end 2stage_pmos_input
