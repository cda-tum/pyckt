.suckt  2stage_pmos_input ibias in1 in2 out source_nmos source_pmos
M1 net_0 in1 net_1 net_1 pmos W=71e-6 L=1e-6
M2 outfirststage in2 net_1 net_1 pmos W=71e-6 L=1e-6
M3 net_2 net_2 source_pmos source_pmos pmos W=1e-6 L=2e-6
M4 net_0 net_0 net_2 net_2 pmos W=1e-6 L=2e-6
M5 net_3 net_2 source_pmos source_pmos pmos W=1e-6 L=2e-6
M6 outfirststage net_0 net_3 net_3 pmos W=1e-6 L=2e-6
M7 net_4 bias_n_2b source_nmos source_nmos nmos W=1e-6 L=2e-6
M8 net_0 bias_n_2t net_4 net_4 nmos W=1e-6 L=2e-6
M9 net_7 bias_n_2b source_nmos source_nmos nmos W=1e-6 L=2e-6
M10 outfirststage bias_n_2t net_7 net_7 nmos W=1e-6 L=2e-6
M11 net_8 ibias source_pmos source_pmos pmos W=1e-6 L=1e-6
M12 net_1 bias_p_3 net_8 net_8 pmos W=2e-6 L=1e-6
M13 net_11 outfirststage source_pmos source_pmos pmos W=1e-6 L=1e-6
M14 out bias_p_3 net_11 net_11 pmos W=49e-6 L=1e-6
M15 net_13 net_13 source_nmos source_nmos nmos W=2e-6 L=1e-6
M16 out net_14 net_13 net_13 nmos W=2e-6 L=1e-6
M17 net_14 net_14 bias_n_1m bias_n_1m nmos W=2e-6 L=1e-6
M18 bias_n_1m net_13 source_nmos source_nmos nmos W=2e-6 L=1e-6
M19 bias_n_2b bias_n_2b source_nmos source_nmos nmos W=1e-6 L=2e-6
M20 bias_n_2t bias_n_2t bias_n_2b bias_n_2b nmos W=1e-6 L=2e-6
M21 bias_p_3 bias_p_3 source_pmos source_pmos pmos W=1e-6 L=12e-6
M22 ibias ibias source_pmos source_pmos pmos W=1e-6 L=1e-6
M23 bias_n_2t ibias source_pmos source_pmos pmos W=1e-6 L=1e-6
M24 bias_p_3 bias_n_2b source_nmos source_nmos nmos W=1e-6 L=2e-6
M25 net_14 ibias source_pmos source_pmos pmos W=1e-6 L=1e-6
Cap_load_1 out source_nmos
Cap_compensation_1 outfirststage out
.end 2stage_pmos_input
