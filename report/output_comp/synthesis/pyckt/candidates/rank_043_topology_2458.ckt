.suckt  1stage_pmos_input ibias in1 in2 out source_nmos source_pmos
M1 net_0 in1 net_1 net_1 pmos W=999e-6 L=1e-6
M2 out in2 net_1 net_1 pmos W=999e-6 L=1e-6
M3 net_0 net_0 source_pmos source_pmos pmos W=1e-6 L=6e-6
M4 net_2 net_0 source_pmos source_pmos pmos W=1e-6 L=6e-6
M5 out bias_p_3 net_2 net_2 pmos W=8e-6 L=6e-6
M6 net_0 ibias source_nmos source_nmos nmos W=1e-6 L=6e-6
M7 out ibias source_nmos source_nmos nmos W=1e-6 L=6e-6
M8 net_5 net_5 source_pmos source_pmos pmos W=1e-6 L=2e-6
M9 net_1 net_6 net_5 net_5 pmos W=1e-6 L=2e-6
M10 ibias ibias source_nmos source_nmos nmos W=1e-6 L=6e-6
M11 net_6 net_6 bias_p_2m bias_p_2m pmos W=1e-6 L=2e-6
M12 bias_p_2m net_5 source_pmos source_pmos pmos W=1e-6 L=2e-6
M13 bias_p_3 bias_p_3 source_pmos source_pmos pmos W=1e-6 L=34e-6
M14 net_6 ibias source_nmos source_nmos nmos W=1e-6 L=6e-6
M15 bias_p_3 ibias source_nmos source_nmos nmos W=1e-6 L=6e-6
Cap_load_1 out source_nmos
.end 1stage_pmos_input
