.suckt  2stage_pmos_input ibias in1 in2 out source_nmos source_pmos
M1 net_0 in1 net_1 net_1 pmos W=25e-6 L=1e-6
M2 outfirststage in2 net_1 net_1 pmos W=25e-6 L=1e-6
M3 net_0 net_0 source_pmos source_pmos pmos W=1e-6 L=20e-6
M4 outfirststage net_0 source_pmos source_pmos pmos W=1e-6 L=20e-6
M5 net_0 bias_n_2 source_nmos source_nmos nmos W=1e-6 L=1e-6
M6 outfirststage bias_n_2 source_nmos source_nmos nmos W=1e-6 L=1e-6
M7 net_3 net_3 source_pmos source_pmos pmos W=1e-6 L=3e-6
M8 net_1 ibias net_3 net_3 pmos W=1e-6 L=3e-6
M9 out outfirststage source_pmos source_pmos pmos W=1e-6 L=1e-6
M10 net_5 net_5 source_nmos source_nmos nmos W=2e-6 L=1e-6
M11 out net_6 net_5 net_5 nmos W=2e-6 L=1e-6
M12 net_6 net_6 bias_n_1m bias_n_1m nmos W=2e-6 L=1e-6
M13 bias_n_1m net_5 source_nmos source_nmos nmos W=2e-6 L=1e-6
M14 bias_n_2 bias_n_2 source_nmos source_nmos nmos W=1e-6 L=1e-6
M15 ibias ibias bias_p_3m bias_p_3m pmos W=1e-6 L=3e-6
M16 bias_p_3m net_3 source_pmos source_pmos pmos W=1e-6 L=3e-6
M17 bias_n_2 net_3 source_pmos source_pmos pmos W=1e-6 L=3e-6
M18 net_6 net_3 source_pmos source_pmos pmos W=1e-6 L=3e-6
Cap_load_1 out source_nmos
Cap_compensation_1 outfirststage out
.end 2stage_pmos_input
