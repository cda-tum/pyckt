.suckt  2stage_pmos_input ibias in1 in2 out source_nmos source_pmos
M1 net_0 in1 net_1 net_1 pmos W=25e-6 L=1e-6
M2 net_2 in2 net_1 net_1 pmos W=25e-6 L=1e-6
M3 net_0 ibias source_nmos source_nmos nmos W=1e-6 L=1e-6
M4 net_4 bias_n_1 net_0 net_0 nmos W=25e-6 L=1e-6
M5 net_2 ibias source_nmos source_nmos nmos W=1e-6 L=1e-6
M6 outfirststage bias_n_1 net_2 net_2 nmos W=25e-6 L=1e-6
M7 net_4 net_4 source_pmos source_pmos pmos W=1e-6 L=1e-6
M8 net_6 net_4 source_pmos source_pmos pmos W=1e-6 L=1e-6
M9 outfirststage bias_p_5 net_6 net_6 pmos W=1e-6 L=1e-6
M10 net_8 net_8 source_pmos source_pmos pmos W=1e-6 L=1e-6
M11 net_1 net_9 net_8 net_8 pmos W=1e-6 L=1e-6
M12 net_10 net_10 source_pmos source_pmos pmos W=1e-6 L=1e-6
M13 out net_11 net_10 net_10 pmos W=1e-6 L=1e-6
M14 net_12 outfirststage source_nmos source_nmos nmos W=1e-6 L=1e-6
M15 out bias_n_1 net_12 net_12 nmos W=32e-6 L=1e-6
M16 bias_n_1 bias_n_1 source_nmos source_nmos nmos W=1e-6 L=1e-6
M17 ibias ibias source_nmos source_nmos nmos W=1e-6 L=1e-6
M18 net_9 net_9 bias_p_3m bias_p_3m pmos W=1e-6 L=1e-6
M19 bias_p_3m net_8 source_pmos source_pmos pmos W=1e-6 L=1e-6
M20 net_11 net_11 bias_p_4m bias_p_4m pmos W=1e-6 L=1e-6
M21 bias_p_4m net_10 source_pmos source_pmos pmos W=1e-6 L=1e-6
M22 bias_p_5 bias_p_5 source_pmos source_pmos pmos W=1e-6 L=7e-6
M23 bias_p_6 bias_p_6 source_pmos source_pmos pmos W=1e-6 L=3e-6
M24 net_11 ibias source_nmos source_nmos nmos W=1e-6 L=1e-6
M25 bias_n_1 bias_p_6 source_pmos source_pmos pmos W=1e-6 L=3e-6
M26 bias_p_5 ibias source_nmos source_nmos nmos W=1e-6 L=1e-6
M27 net_9 ibias source_nmos source_nmos nmos W=1e-6 L=1e-6
M28 bias_p_6 ibias source_nmos source_nmos nmos W=1e-6 L=1e-6
Cap_load_1 out source_nmos
Cap_compensation_1 outfirststage out
.end 2stage_pmos_input
