.suckt  symmetrical_op_amp_4094 ibias in1 in2 out source_nmos source_pmos
M1 out1fs in1 net_0 net_0 pmos W=1000e-6 L=1e-6
M2 out2fs in2 net_0 net_0 pmos W=1000e-6 L=1e-6
M3 out1fs out1fs source_nmos source_nmos nmos W=1e-6 L=1e-6
M4 out2fs out2fs source_nmos source_nmos nmos W=1e-6 L=2e-6
M5 net_0 ibias source_pmos source_pmos pmos W=1e-6 L=1e-6
M6 out instagebias source_pmos source_pmos pmos W=2e-6 L=1e-6
M7 net_2 out1fs source_nmos source_nmos nmos W=1e-6 L=1e-6
M8 out bias_n_1 net_2 net_2 nmos W=2e-6 L=1e-6
M9 net_3 out2fs source_nmos source_nmos nmos W=1e-6 L=2e-6
M10 instagebias bias_n_1 net_3 net_3 nmos W=1e-6 L=1e-6
M11 instagebias instagebias source_pmos source_pmos pmos W=2e-6 L=1e-6
M12 bias_n_1 bias_n_1 source_nmos source_nmos nmos W=1e-6 L=1e-6
M13 ibias ibias source_pmos source_pmos pmos W=1e-6 L=1e-6
M14 bias_n_1 ibias source_pmos source_pmos pmos W=1e-6 L=1e-6
Cap_load_1 out source_nmos
.end symmetrical_op_amp_4094
