.suckt  1stage_nmos_input ibias in1 in2 out source_nmos source_pmos
M1 net_0 in1 net_1 net_1 nmos W=970e-6 L=1e-6
M2 out in2 net_1 net_1 nmos W=970e-6 L=1e-6
M3 net_0 net_0 source_pmos source_pmos pmos W=2e-6 L=1e-6
M4 out net_0 source_pmos source_pmos pmos W=2e-6 L=1e-6
M5 net_2 net_2 source_nmos source_nmos nmos W=1e-6 L=1e-6
M6 net_1 ibias net_2 net_2 nmos W=1e-6 L=1e-6
M7 ibias ibias bias_n_1m bias_n_1m nmos W=1e-6 L=1e-6
M8 bias_n_1m net_2 source_nmos source_nmos nmos W=1e-6 L=1e-6
Cap_load_1 out source_nmos
.end 1stage_nmos_input
