.suckt  2stage_nmos_input ibias in1 in2 out source_nmos source_pmos
M1 net_0 in1 net_1 net_1 nmos W=4e-6 L=1e-6
M2 net_2 in2 net_1 net_1 nmos W=4e-6 L=1e-6
M3 net_3 net_4 net_0 net_0 nmos W=4e-6 L=1e-6
M4 outfirststage net_4 net_2 net_2 nmos W=4e-6 L=1e-6
M5 net_5 net_5 source_pmos source_pmos pmos W=1e-6 L=1e-6
M6 net_3 net_3 net_5 net_5 pmos W=1e-6 L=1e-6
M7 net_6 net_5 source_pmos source_pmos pmos W=1e-6 L=1e-6
M8 outfirststage net_3 net_6 net_6 pmos W=1e-6 L=1e-6
M9 net_1 bias_n_2 source_nmos source_nmos nmos W=1e-6 L=1e-6
M10 net_8 bias_p_3b source_pmos source_pmos pmos W=1e-6 L=1e-6
M11 out ibias net_8 net_8 pmos W=1e-6 L=1e-6
M12 net_11 outfirststage source_nmos source_nmos nmos W=1e-6 L=1e-6
M13 out bias_n_1 net_11 net_11 nmos W=13e-6 L=1e-6
M14 net_4 net_4 net_1 net_1 nmos W=1e-6 L=1e-6
M15 bias_n_1 bias_n_1 source_nmos source_nmos nmos W=1e-6 L=1e-6
M16 bias_n_2 bias_n_2 source_nmos source_nmos nmos W=1e-6 L=1e-6
M17 bias_p_3b bias_p_3b source_pmos source_pmos pmos W=1e-6 L=1e-6
M18 ibias ibias bias_p_3b bias_p_3b pmos W=1e-6 L=1e-6
M19 bias_n_2 bias_p_3b source_pmos source_pmos pmos W=1e-6 L=1e-6
M20 net_4 bias_p_3b source_pmos source_pmos pmos W=1e-6 L=1e-6
M21 bias_n_1 bias_p_3b source_pmos source_pmos pmos W=1e-6 L=1e-6
Cap_load_1 out source_nmos
Cap_compensation_1 outfirststage out
.end 2stage_nmos_input
