.suckt  2stage_nmos_input ibias in1 in2 out source_nmos source_pmos
M1 net_0 in1 net_1 net_1 nmos W=4e-6 L=1e-6
M2 outfirststage in2 net_1 net_1 nmos W=4e-6 L=1e-6
M3 net_2 net_2 source_nmos source_nmos nmos W=1e-6 L=1e-6
M4 net_0 net_0 net_2 net_2 nmos W=1e-6 L=1e-6
M5 net_3 net_2 source_nmos source_nmos nmos W=1e-6 L=1e-6
M6 outfirststage net_0 net_3 net_3 nmos W=1e-6 L=1e-6
M7 net_0 bias_p_4 source_pmos source_pmos pmos W=1e-6 L=1e-6
M8 outfirststage bias_p_4 source_pmos source_pmos pmos W=1e-6 L=1e-6
M9 net_5 bias_n_2b source_nmos source_nmos nmos W=1e-6 L=1e-6
M10 net_1 ibias net_5 net_5 nmos W=1e-6 L=1e-6
M11 net_8 outfirststage source_pmos source_pmos pmos W=1e-6 L=1e-6
M12 out bias_p_3 net_8 net_8 pmos W=4e-6 L=1e-6
M13 net_10 net_10 source_nmos source_nmos nmos W=2e-6 L=1e-6
M14 out net_11 net_10 net_10 nmos W=2e-6 L=1e-6
M15 net_11 net_11 bias_n_1m bias_n_1m nmos W=2e-6 L=1e-6
M16 bias_n_1m net_10 source_nmos source_nmos nmos W=2e-6 L=1e-6
M17 bias_n_2b bias_n_2b source_nmos source_nmos nmos W=1e-6 L=1e-6
M18 ibias ibias bias_n_2b bias_n_2b nmos W=1e-6 L=1e-6
M19 bias_p_3 bias_p_3 source_pmos source_pmos pmos W=1e-6 L=10e-6
M20 bias_p_4 bias_p_4 source_pmos source_pmos pmos W=1e-6 L=1e-6
M21 bias_p_4 bias_n_2b source_nmos source_nmos nmos W=1e-6 L=1e-6
M22 bias_p_3 bias_n_2b source_nmos source_nmos nmos W=1e-6 L=1e-6
M23 net_11 bias_p_4 source_pmos source_pmos pmos W=1e-6 L=1e-6
Cap_load_1 out source_nmos
Cap_compensation_1 outfirststage out
.end 2stage_nmos_input
