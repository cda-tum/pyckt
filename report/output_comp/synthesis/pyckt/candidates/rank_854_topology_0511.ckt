.suckt  2stage_nmos_input ibias in1 in2 out source_nmos source_pmos
M1 net_0 in1 net_1 net_1 nmos W=4e-6 L=1e-6
M2 outfirststage in2 net_1 net_1 nmos W=4e-6 L=1e-6
M3 net_0 net_0 source_pmos source_pmos pmos W=1e-6 L=1e-6
M4 net_2 net_0 source_pmos source_pmos pmos W=1e-6 L=1e-6
M5 outfirststage bias_p_2 net_2 net_2 pmos W=2e-6 L=1e-6
M6 net_4 net_4 source_nmos source_nmos nmos W=1e-6 L=1e-6
M7 net_1 ibias net_4 net_4 nmos W=1e-6 L=1e-6
M8 net_6 bias_p_3 source_pmos source_pmos pmos W=1e-6 L=1e-6
M9 out bias_p_2 net_6 net_6 pmos W=2e-6 L=1e-6
M10 out outfirststage source_nmos source_nmos nmos W=2e-6 L=1e-6
M11 ibias ibias bias_n_1m bias_n_1m nmos W=1e-6 L=1e-6
M12 bias_n_1m net_4 source_nmos source_nmos nmos W=1e-6 L=1e-6
M13 bias_p_2 bias_p_2 source_pmos source_pmos pmos W=1e-6 L=21e-6
M14 bias_p_3 bias_p_3 source_pmos source_pmos pmos W=1e-6 L=1e-6
M15 bias_p_3 net_4 source_nmos source_nmos nmos W=1e-6 L=1e-6
M16 bias_p_2 net_4 source_nmos source_nmos nmos W=1e-6 L=1e-6
Cap_load_1 out source_nmos
Cap_compensation_1 outfirststage out
.end 2stage_nmos_input
