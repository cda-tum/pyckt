.suckt  2stage_pmos_input ibias in1 in2 out source_nmos source_pmos
M1 net_0 in1 net_1 net_1 pmos W=26e-6 L=1e-6
M2 outfirststage in2 net_1 net_1 pmos W=26e-6 L=1e-6
M3 net_2 net_3 source_nmos source_nmos nmos W=1e-6 L=1e-6
M4 net_0 net_0 net_2 net_2 nmos W=1e-6 L=1e-6
M5 net_3 net_3 source_nmos source_nmos nmos W=1e-6 L=1e-6
M6 outfirststage net_0 net_3 net_3 nmos W=1e-6 L=1e-6
M7 net_1 ibias source_pmos source_pmos pmos W=11e-6 L=1e-6
M8 out ibias source_pmos source_pmos pmos W=11e-6 L=1e-6
M9 net_6 outfirststage source_nmos source_nmos nmos W=1e-6 L=1e-6
M10 out bias_n_1 net_6 net_6 nmos W=2e-6 L=1e-6
M11 bias_n_1 bias_n_1 source_nmos source_nmos nmos W=1e-6 L=1e-6
M12 ibias ibias source_pmos source_pmos pmos W=11e-6 L=1e-6
M13 bias_n_1 ibias source_pmos source_pmos pmos W=11e-6 L=1e-6
Cap_load_1 out source_nmos
Cap_compensation_1 outfirststage out
.end 2stage_pmos_input
