.suckt  symmetrical_op_amp_4205 ibias in1 in2 out source_nmos source_pmos
M1 out1fs in1 net_0 net_0 nmos W=3e-6 L=1e-6
M2 insourcetc in2 net_0 net_0 nmos W=3e-6 L=1e-6
M3 net_1 out1fs source_pmos source_pmos pmos W=7e-6 L=1e-6
M4 out1fs bias_p_2 net_1 net_1 pmos W=7e-6 L=1e-6
M5 net_2 insourcetc source_pmos source_pmos pmos W=1e-6 L=1e-6
M6 insourcetc bias_p_2 net_2 net_2 pmos W=1e-6 L=1e-6
M7 net_0 ibias source_nmos source_nmos nmos W=1e-6 L=1e-6
M8 net_4 out1fs source_pmos source_pmos pmos W=7e-6 L=1e-6
M9 out bias_p_2 net_4 net_4 pmos W=7e-6 L=1e-6
M10 out instagebias source_nmos source_nmos nmos W=2e-6 L=1e-6
M11 net_5 insourcetc source_pmos source_pmos pmos W=1e-6 L=1e-6
M12 instagebias bias_p_2 net_5 net_5 pmos W=1e-6 L=1e-6
M13 instagebias instagebias source_nmos source_nmos nmos W=2e-6 L=1e-6
M14 ibias ibias source_nmos source_nmos nmos W=1e-6 L=1e-6
M15 bias_p_2 bias_p_2 source_pmos source_pmos pmos W=1e-6 L=4e-6
M16 bias_p_2 ibias source_nmos source_nmos nmos W=1e-6 L=1e-6
Cap_load_1 out source_nmos
.end symmetrical_op_amp_4205
