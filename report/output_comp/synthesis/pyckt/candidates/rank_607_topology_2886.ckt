.suckt  2stage_nmos_input ibias in1 in2 out source_nmos source_pmos
M1 net_0 in1 net_1 net_1 nmos W=4e-6 L=1e-6
M2 outfirststage in2 net_1 net_1 nmos W=4e-6 L=1e-6
M3 net_0 net_0 source_nmos source_nmos nmos W=1e-6 L=2e-6
M4 net_2 net_0 source_nmos source_nmos nmos W=1e-6 L=2e-6
M5 outfirststage bias_n_3 net_2 net_2 nmos W=1e-6 L=2e-6
M6 net_0 ibias source_pmos source_pmos pmos W=1e-6 L=2e-6
M7 outfirststage ibias source_pmos source_pmos pmos W=1e-6 L=2e-6
M8 net_5 net_5 source_nmos source_nmos nmos W=1e-6 L=1e-6
M9 net_1 net_6 net_5 net_5 nmos W=1e-6 L=1e-6
M10 net_7 outfirststage source_pmos source_pmos pmos W=1e-6 L=1e-6
M11 out bias_p_4 net_7 net_7 pmos W=7e-6 L=1e-6
M12 net_9 net_9 source_nmos source_nmos nmos W=2e-6 L=1e-6
M13 out net_10 net_9 net_9 nmos W=2e-6 L=1e-6
M14 net_6 net_6 bias_n_1m bias_n_1m nmos W=1e-6 L=1e-6
M15 bias_n_1m net_5 source_nmos source_nmos nmos W=1e-6 L=1e-6
M16 net_10 net_10 bias_n_2m bias_n_2m nmos W=2e-6 L=1e-6
M17 bias_n_2m net_9 source_nmos source_nmos nmos W=2e-6 L=1e-6
M18 bias_n_3 bias_n_3 source_nmos source_nmos nmos W=1e-6 L=1e-6
M19 bias_p_4 bias_p_4 source_pmos source_pmos pmos W=1e-6 L=9e-6
M20 ibias ibias source_pmos source_pmos pmos W=1e-6 L=2e-6
M21 bias_n_6 bias_n_6 source_nmos source_nmos nmos W=1e-6 L=1e-6
M22 net_10 ibias source_pmos source_pmos pmos W=1e-6 L=2e-6
M23 bias_n_3 ibias source_pmos source_pmos pmos W=1e-6 L=2e-6
M24 bias_p_4 bias_n_6 source_nmos source_nmos nmos W=1e-6 L=1e-6
M25 net_6 ibias source_pmos source_pmos pmos W=1e-6 L=2e-6
M26 bias_n_6 ibias source_pmos source_pmos pmos W=1e-6 L=2e-6
Cap_load_1 out source_nmos
Cap_compensation_1 outfirststage out
.end 2stage_nmos_input
