.suckt  2stage_pmos_input ibias in1 in2 out source_nmos source_pmos
M1 net_0 in1 net_1 net_1 pmos W=72e-6 L=1e-6
M2 outfirststage in2 net_1 net_1 pmos W=72e-6 L=1e-6
M3 net_2 net_2 source_pmos source_pmos pmos W=1e-6 L=2e-6
M4 net_0 net_0 net_2 net_2 pmos W=1e-6 L=2e-6
M5 net_3 net_2 source_pmos source_pmos pmos W=1e-6 L=2e-6
M6 outfirststage net_0 net_3 net_3 pmos W=1e-6 L=2e-6
M7 net_0 bias_n_2 source_nmos source_nmos nmos W=1e-6 L=2e-6
M8 outfirststage bias_n_2 source_nmos source_nmos nmos W=1e-6 L=2e-6
M9 net_5 ibias source_pmos source_pmos pmos W=1e-6 L=1e-6
M10 net_1 bias_p_3 net_5 net_5 pmos W=2e-6 L=1e-6
M11 net_8 outfirststage source_pmos source_pmos pmos W=1e-6 L=1e-6
M12 out bias_p_3 net_8 net_8 pmos W=53e-6 L=1e-6
M13 net_10 net_10 source_nmos source_nmos nmos W=2e-6 L=1e-6
M14 out net_11 net_10 net_10 nmos W=2e-6 L=1e-6
M15 net_11 net_11 bias_n_1m bias_n_1m nmos W=2e-6 L=1e-6
M16 bias_n_1m net_10 source_nmos source_nmos nmos W=2e-6 L=1e-6
M17 bias_n_2 bias_n_2 source_nmos source_nmos nmos W=1e-6 L=2e-6
M18 bias_p_3 bias_p_3 source_pmos source_pmos pmos W=1e-6 L=12e-6
M19 ibias ibias source_pmos source_pmos pmos W=1e-6 L=1e-6
M20 bias_n_2 ibias source_pmos source_pmos pmos W=1e-6 L=1e-6
M21 bias_p_3 bias_n_2 source_nmos source_nmos nmos W=1e-6 L=2e-6
M22 net_11 ibias source_pmos source_pmos pmos W=1e-6 L=1e-6
Cap_load_1 out source_nmos
Cap_compensation_1 outfirststage out
.end 2stage_pmos_input
