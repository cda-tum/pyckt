.suckt  1stage_nmos_input ibias in1 in2 out source_nmos source_pmos
M1 net_0 in1 net_1 net_1 nmos W=991e-6 L=1e-6
M2 out in2 net_1 net_1 nmos W=991e-6 L=1e-6
M3 net_0 net_0 source_nmos source_nmos nmos W=1e-6 L=1e-6
M4 net_2 net_0 source_nmos source_nmos nmos W=1e-6 L=1e-6
M5 out bias_n_1 net_2 net_2 nmos W=16e-6 L=1e-6
M6 net_0 ibias source_pmos source_pmos pmos W=1e-6 L=1e-6
M7 out ibias source_pmos source_pmos pmos W=1e-6 L=1e-6
M8 net_5 bias_n_2 source_nmos source_nmos nmos W=1e-6 L=1e-6
M9 net_1 bias_n_1 net_5 net_5 nmos W=1e-6 L=2e-6
M10 bias_n_1 bias_n_1 source_nmos source_nmos nmos W=1e-6 L=1e-6
M11 bias_n_2 bias_n_2 source_nmos source_nmos nmos W=1e-6 L=1e-6
M12 ibias ibias source_pmos source_pmos pmos W=1e-6 L=1e-6
M13 bias_n_2 ibias source_pmos source_pmos pmos W=1e-6 L=1e-6
M14 bias_n_1 ibias source_pmos source_pmos pmos W=1e-6 L=1e-6
Cap_load_1 out source_nmos
.end 1stage_nmos_input
