.suckt  2stage_pmos_input ibias in1 in2 out source_nmos source_pmos
M1 net_0 in1 net_1 net_1 pmos W=25e-6 L=1e-6
M2 outfirststage in2 net_1 net_1 pmos W=25e-6 L=1e-6
M3 net_0 net_0 source_nmos source_nmos nmos W=1e-6 L=1e-6
M4 net_2 net_0 source_nmos source_nmos nmos W=1e-6 L=1e-6
M5 outfirststage bias_n_2 net_2 net_2 nmos W=1e-6 L=1e-6
M6 net_4 bias_p_3b source_pmos source_pmos pmos W=1e-6 L=2e-6
M7 net_1 ibias net_4 net_4 pmos W=1e-6 L=2e-6
M8 out outfirststage source_pmos source_pmos pmos W=1e-6 L=1e-6
M9 net_7 net_7 source_nmos source_nmos nmos W=2e-6 L=1e-6
M10 out net_8 net_7 net_7 nmos W=2e-6 L=1e-6
M11 net_8 net_8 bias_n_1m bias_n_1m nmos W=2e-6 L=1e-6
M12 bias_n_1m net_7 source_nmos source_nmos nmos W=2e-6 L=1e-6
M13 bias_n_2 bias_n_2 source_nmos source_nmos nmos W=1e-6 L=1e-6
M14 bias_p_3b bias_p_3b source_pmos source_pmos pmos W=1e-6 L=2e-6
M15 ibias ibias bias_p_3b bias_p_3b pmos W=1e-6 L=2e-6
M16 net_8 bias_p_3b source_pmos source_pmos pmos W=1e-6 L=2e-6
M17 bias_n_2 bias_p_3b source_pmos source_pmos pmos W=1e-6 L=2e-6
Cap_load_1 out source_nmos
Cap_compensation_1 outfirststage out
.end 2stage_pmos_input
