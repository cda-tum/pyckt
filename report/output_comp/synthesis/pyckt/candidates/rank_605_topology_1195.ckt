.suckt  2stage_nmos_input ibias in1 in2 out source_nmos source_pmos
M1 net_0 in1 net_1 net_1 nmos W=4e-6 L=1e-6
M2 net_2 in2 net_1 net_1 nmos W=4e-6 L=1e-6
M3 net_0 ibias source_pmos source_pmos pmos W=1e-6 L=1e-6
M4 net_4 bias_p_4 net_0 net_0 pmos W=4e-6 L=1e-6
M5 net_2 ibias source_pmos source_pmos pmos W=1e-6 L=1e-6
M6 outfirststage bias_p_4 net_2 net_2 pmos W=4e-6 L=1e-6
M7 net_6 net_4 source_nmos source_nmos nmos W=3e-6 L=1e-6
M8 net_4 bias_n_2 net_6 net_6 nmos W=3e-6 L=1e-6
M9 net_8 net_4 source_nmos source_nmos nmos W=3e-6 L=1e-6
M10 outfirststage bias_n_2 net_8 net_8 nmos W=3e-6 L=1e-6
M11 net_9 net_9 source_nmos source_nmos nmos W=1e-6 L=1e-6
M12 net_1 net_10 net_9 net_9 nmos W=1e-6 L=1e-6
M13 net_11 outfirststage source_pmos source_pmos pmos W=1e-6 L=1e-6
M14 out bias_p_4 net_11 net_11 pmos W=10e-6 L=1e-6
M15 net_13 bias_n_3 source_nmos source_nmos nmos W=1e-6 L=1e-6
M16 out bias_n_2 net_13 net_13 nmos W=2e-6 L=1e-6
M17 net_10 net_10 bias_n_1m bias_n_1m nmos W=1e-6 L=1e-6
M18 bias_n_1m net_9 source_nmos source_nmos nmos W=1e-6 L=1e-6
M19 bias_n_2 bias_n_2 source_nmos source_nmos nmos W=1e-6 L=1e-6
M20 bias_n_3 bias_n_3 source_nmos source_nmos nmos W=1e-6 L=1e-6
M21 bias_p_4 bias_p_4 source_pmos source_pmos pmos W=1e-6 L=5e-6
M22 ibias ibias source_pmos source_pmos pmos W=1e-6 L=1e-6
M23 bias_n_3 ibias source_pmos source_pmos pmos W=1e-6 L=1e-6
M24 bias_n_2 ibias source_pmos source_pmos pmos W=1e-6 L=1e-6
M25 bias_p_4 bias_n_3 source_nmos source_nmos nmos W=1e-6 L=1e-6
M26 net_10 ibias source_pmos source_pmos pmos W=1e-6 L=1e-6
Cap_load_1 out source_nmos
Cap_compensation_1 outfirststage out
.end 2stage_nmos_input
