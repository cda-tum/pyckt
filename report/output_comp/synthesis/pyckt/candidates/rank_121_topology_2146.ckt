.suckt  1stage_nmos_input ibias in1 in2 out source_nmos source_pmos
M1 net_0 in1 net_1 net_1 nmos W=3e-6 L=1e-6
M2 out in2 net_1 net_1 nmos W=3e-6 L=1e-6
M3 net_0 net_2 source_nmos source_nmos nmos W=1e-6 L=1e-6
M4 net_2 net_2 source_nmos source_nmos nmos W=1e-6 L=1e-6
M5 out net_0 net_2 net_2 nmos W=1e-6 L=1e-6
M6 net_3 bias_p_2b source_pmos source_pmos pmos W=1e-6 L=1e-6
M7 net_0 bias_p_2t net_3 net_3 pmos W=1e-6 L=1e-6
M8 net_6 bias_p_2b source_pmos source_pmos pmos W=1e-6 L=1e-6
M9 out bias_p_2t net_6 net_6 pmos W=1e-6 L=1e-6
M10 net_1 ibias source_nmos source_nmos nmos W=1e-6 L=1e-6
M11 ibias ibias source_nmos source_nmos nmos W=1e-6 L=1e-6
M12 bias_p_2b bias_p_2b source_pmos source_pmos pmos W=1e-6 L=1e-6
M13 bias_p_2t bias_p_2t bias_p_2b bias_p_2b pmos W=1e-6 L=1e-6
M14 bias_p_2t ibias source_nmos source_nmos nmos W=1e-6 L=1e-6
Cap_load_1 out source_nmos
.end 1stage_nmos_input
