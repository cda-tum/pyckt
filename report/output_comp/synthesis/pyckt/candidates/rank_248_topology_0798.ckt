.suckt  2stage_nmos_input ibias in1 in2 out source_nmos source_pmos
M1 net_0 in1 net_1 net_1 nmos W=3e-6 L=1e-6
M2 net_2 in2 net_1 net_1 nmos W=3e-6 L=1e-6
M3 net_0 bias_p_3b source_pmos source_pmos pmos W=3e-6 L=1e-6
M4 net_4 ibias net_0 net_0 pmos W=3e-6 L=1e-6
M5 net_2 bias_p_3b source_pmos source_pmos pmos W=3e-6 L=1e-6
M6 outfirststage ibias net_2 net_2 pmos W=3e-6 L=1e-6
M7 net_6 net_4 source_nmos source_nmos nmos W=1e-6 L=1e-6
M8 net_4 bias_n_1 net_6 net_6 nmos W=1e-6 L=1e-6
M9 net_8 net_4 source_nmos source_nmos nmos W=1e-6 L=1e-6
M10 outfirststage bias_n_1 net_8 net_8 nmos W=1e-6 L=1e-6
M11 net_1 bias_n_2 source_nmos source_nmos nmos W=1e-6 L=1e-6
M12 net_10 bias_p_3b source_pmos source_pmos pmos W=3e-6 L=1e-6
M13 out ibias net_10 net_10 pmos W=3e-6 L=1e-6
M14 net_13 outfirststage source_nmos source_nmos nmos W=1e-6 L=1e-6
M15 out bias_n_1 net_13 net_13 nmos W=31e-6 L=1e-6
M16 bias_n_1 bias_n_1 source_nmos source_nmos nmos W=1e-6 L=1e-6
M17 bias_n_2 bias_n_2 source_nmos source_nmos nmos W=1e-6 L=1e-6
M18 bias_p_3b bias_p_3b source_pmos source_pmos pmos W=3e-6 L=1e-6
M19 ibias ibias bias_p_3b bias_p_3b pmos W=3e-6 L=1e-6
M20 bias_n_2 bias_p_3b source_pmos source_pmos pmos W=3e-6 L=1e-6
M21 bias_n_1 bias_p_3b source_pmos source_pmos pmos W=3e-6 L=1e-6
Cap_load_1 out source_nmos
Cap_compensation_1 outfirststage out
.end 2stage_nmos_input
