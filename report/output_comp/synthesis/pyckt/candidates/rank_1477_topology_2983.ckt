.suckt  2stage_nmos_input ibias in1 in2 out source_nmos source_pmos
M1 net_0 in1 net_1 net_1 nmos W=4e-6 L=1e-6
M2 outfirststage in2 net_1 net_1 nmos W=4e-6 L=1e-6
M3 net_2 net_0 source_nmos source_nmos nmos W=1e-6 L=1e-6
M4 net_0 bias_n_2 net_2 net_2 nmos W=1e-6 L=1e-6
M5 net_4 net_0 source_nmos source_nmos nmos W=1e-6 L=1e-6
M6 outfirststage bias_n_2 net_4 net_4 nmos W=1e-6 L=1e-6
M7 net_0 bias_p_4 source_pmos source_pmos pmos W=1e-6 L=1e-6
M8 outfirststage bias_p_4 source_pmos source_pmos pmos W=1e-6 L=1e-6
M9 net_6 net_6 source_nmos source_nmos nmos W=1e-6 L=1e-6
M10 net_1 ibias net_6 net_6 nmos W=1e-6 L=1e-6
M11 net_8 net_8 source_pmos source_pmos pmos W=1e-6 L=1e-6
M12 out net_9 net_8 net_8 pmos W=1e-6 L=1e-6
M13 out outfirststage source_nmos source_nmos nmos W=2e-6 L=1e-6
M14 ibias ibias bias_n_1m bias_n_1m nmos W=1e-6 L=1e-6
M15 bias_n_1m net_6 source_nmos source_nmos nmos W=1e-6 L=1e-6
M16 bias_n_2 bias_n_2 source_nmos source_nmos nmos W=1e-6 L=1e-6
M17 net_9 net_9 bias_p_3m bias_p_3m pmos W=1e-6 L=1e-6
M18 bias_p_3m net_8 source_pmos source_pmos pmos W=1e-6 L=1e-6
M19 bias_p_4 bias_p_4 source_pmos source_pmos pmos W=1e-6 L=1e-6
M20 bias_p_4 net_6 source_nmos source_nmos nmos W=1e-6 L=1e-6
M21 bias_n_2 bias_p_4 source_pmos source_pmos pmos W=1e-6 L=1e-6
M22 net_9 net_6 source_nmos source_nmos nmos W=1e-6 L=1e-6
Cap_load_1 out source_nmos
Cap_compensation_1 outfirststage out
.end 2stage_nmos_input
