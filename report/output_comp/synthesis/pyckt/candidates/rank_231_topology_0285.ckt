.suckt  2stage_pmos_input ibias in1 in2 out source_nmos source_pmos
M1 net_0 in1 net_1 net_1 pmos W=25e-6 L=1e-6
M2 outfirststage in2 net_1 net_1 pmos W=25e-6 L=1e-6
M3 net_0 net_2 source_nmos source_nmos nmos W=1e-6 L=1e-6
M4 net_2 net_2 source_nmos source_nmos nmos W=1e-6 L=1e-6
M5 outfirststage net_0 net_2 net_2 nmos W=1e-6 L=1e-6
M6 net_3 net_3 source_pmos source_pmos pmos W=1e-6 L=2e-6
M7 net_1 net_4 net_3 net_3 pmos W=1e-6 L=2e-6
M8 net_5 outfirststage source_pmos source_pmos pmos W=1e-6 L=2e-6
M9 out bias_p_3 net_5 net_5 pmos W=8e-6 L=2e-6
M10 net_7 bias_n_1b source_nmos source_nmos nmos W=3e-6 L=2e-6
M11 out ibias net_7 net_7 nmos W=3e-6 L=2e-6
M12 bias_n_1b bias_n_1b source_nmos source_nmos nmos W=3e-6 L=2e-6
M13 ibias ibias bias_n_1b bias_n_1b nmos W=3e-6 L=2e-6
M14 net_4 net_4 bias_p_2m bias_p_2m pmos W=1e-6 L=2e-6
M15 bias_p_2m net_3 source_pmos source_pmos pmos W=1e-6 L=2e-6
M16 bias_p_3 bias_p_3 source_pmos source_pmos pmos W=1e-6 L=20e-6
M17 net_4 bias_n_1b source_nmos source_nmos nmos W=3e-6 L=2e-6
M18 bias_p_3 bias_n_1b source_nmos source_nmos nmos W=3e-6 L=2e-6
Cap_load_1 out source_nmos
Cap_compensation_1 outfirststage out
.end 2stage_pmos_input
