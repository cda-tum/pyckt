.suckt  2stage_pmos_input ibias in1 in2 out source_nmos source_pmos
M1 net_0 in1 net_1 net_1 pmos W=25e-6 L=1e-6
M2 net_2 in2 net_1 net_1 pmos W=25e-6 L=1e-6
M3 net_3 net_4 net_0 net_0 pmos W=25e-6 L=1e-6
M4 outfirststage net_4 net_2 net_2 pmos W=25e-6 L=1e-6
M5 net_3 net_5 source_nmos source_nmos nmos W=1e-6 L=1e-6
M6 net_5 net_5 source_nmos source_nmos nmos W=1e-6 L=1e-6
M7 outfirststage net_3 net_5 net_5 nmos W=1e-6 L=1e-6
M8 net_6 net_6 source_pmos source_pmos pmos W=1e-6 L=1e-6
M9 net_1 net_7 net_6 net_6 pmos W=1e-6 L=1e-6
M10 net_8 outfirststage source_pmos source_pmos pmos W=1e-6 L=2e-6
M11 out bias_p_3 net_8 net_8 pmos W=6e-6 L=2e-6
M12 out ibias source_nmos source_nmos nmos W=3e-6 L=2e-6
M13 ibias ibias source_nmos source_nmos nmos W=3e-6 L=2e-6
M14 net_4 net_4 net_1 net_1 pmos W=1e-6 L=1e-6
M15 net_7 net_7 bias_p_2m bias_p_2m pmos W=1e-6 L=1e-6
M16 bias_p_2m net_6 source_pmos source_pmos pmos W=1e-6 L=1e-6
M17 bias_p_3 bias_p_3 source_pmos source_pmos pmos W=1e-6 L=24e-6
M18 net_7 ibias source_nmos source_nmos nmos W=3e-6 L=2e-6
M19 net_4 ibias source_nmos source_nmos nmos W=3e-6 L=2e-6
M20 bias_p_3 ibias source_nmos source_nmos nmos W=3e-6 L=2e-6
Cap_load_1 out source_nmos
Cap_compensation_1 outfirststage out
.end 2stage_pmos_input
