.suckt  2stage_nmos_input ibias in1 in2 out source_nmos source_pmos
M1 net_0 in1 net_1 net_1 nmos W=9e-6 L=1e-6
M2 outfirststage in2 net_1 net_1 nmos W=9e-6 L=1e-6
M3 net_0 net_0 source_nmos source_nmos nmos W=1e-6 L=14e-6
M4 outfirststage net_0 source_nmos source_nmos nmos W=1e-6 L=14e-6
M5 net_2 bias_p_2b source_pmos source_pmos pmos W=1e-6 L=14e-6
M6 net_0 bias_p_2t net_2 net_2 pmos W=1e-6 L=14e-6
M7 net_5 bias_p_2b source_pmos source_pmos pmos W=1e-6 L=14e-6
M8 outfirststage bias_p_2t net_5 net_5 pmos W=1e-6 L=14e-6
M9 net_1 ibias source_nmos source_nmos nmos W=10e-6 L=1e-6
M10 out outfirststage source_pmos source_pmos pmos W=18e-6 L=2e-6
M11 out ibias source_nmos source_nmos nmos W=10e-6 L=1e-6
M12 ibias ibias source_nmos source_nmos nmos W=10e-6 L=1e-6
M13 bias_p_2b bias_p_2b source_pmos source_pmos pmos W=1e-6 L=14e-6
M14 bias_p_2t bias_p_2t bias_p_2b bias_p_2b pmos W=1e-6 L=14e-6
M15 bias_p_2t ibias source_nmos source_nmos nmos W=10e-6 L=1e-6
Cap_load_1 out source_nmos
Cap_compensation_1 outfirststage out
.end 2stage_nmos_input
