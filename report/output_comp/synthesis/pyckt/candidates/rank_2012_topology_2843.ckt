.suckt  2stage_nmos_input ibias in1 in2 out source_nmos source_pmos
M1 net_0 in1 net_1 net_1 nmos W=10e-6 L=1e-6
M2 outfirststage in2 net_1 net_1 nmos W=10e-6 L=1e-6
M3 net_0 net_2 source_nmos source_nmos nmos W=1e-6 L=2e-6
M4 net_2 net_2 source_nmos source_nmos nmos W=1e-6 L=2e-6
M5 outfirststage net_0 net_2 net_2 nmos W=1e-6 L=2e-6
M6 net_3 bias_p_2b source_pmos source_pmos pmos W=1e-6 L=2e-6
M7 net_0 bias_p_2t net_3 net_3 pmos W=1e-6 L=2e-6
M8 net_6 bias_p_2b source_pmos source_pmos pmos W=1e-6 L=2e-6
M9 outfirststage bias_p_2t net_6 net_6 pmos W=1e-6 L=2e-6
M10 net_7 bias_n_1b source_nmos source_nmos nmos W=3e-6 L=1e-6
M11 net_1 ibias net_7 net_7 nmos W=3e-6 L=1e-6
M12 out outfirststage source_pmos source_pmos pmos W=1e-6 L=1e-6
M13 net_10 bias_n_1b source_nmos source_nmos nmos W=3e-6 L=1e-6
M14 out ibias net_10 net_10 nmos W=3e-6 L=1e-6
M15 bias_n_1b bias_n_1b source_nmos source_nmos nmos W=3e-6 L=1e-6
M16 ibias ibias bias_n_1b bias_n_1b nmos W=3e-6 L=1e-6
M17 bias_p_2b bias_p_2b source_pmos source_pmos pmos W=1e-6 L=2e-6
M18 bias_p_2t bias_p_2t bias_p_2b bias_p_2b pmos W=1e-6 L=2e-6
M19 bias_p_2t bias_n_1b source_nmos source_nmos nmos W=3e-6 L=1e-6
Cap_load_1 out source_nmos
Cap_compensation_1 outfirststage out
.end 2stage_nmos_input
