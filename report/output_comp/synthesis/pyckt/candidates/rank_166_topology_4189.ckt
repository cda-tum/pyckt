.suckt  symmetrical_op_amp_4189 ibias in1 in2 out source_nmos source_pmos
M1 out1fs in1 net_0 net_0 pmos W=15e-6 L=1e-6
M2 insourcetc in2 net_0 net_0 pmos W=15e-6 L=1e-6
M3 net_1 out1fs source_nmos source_nmos nmos W=3e-6 L=1e-6
M4 out1fs bias_n_1 net_1 net_1 nmos W=3e-6 L=1e-6
M5 net_2 insourcetc source_nmos source_nmos nmos W=1e-6 L=1e-6
M6 insourcetc bias_n_1 net_2 net_2 nmos W=1e-6 L=1e-6
M7 net_0 ibias source_pmos source_pmos pmos W=1e-6 L=1e-6
M8 instagebias instagebias source_pmos source_pmos pmos W=7e-6 L=1e-6
M9 out innercomp instagebias instagebias pmos W=7e-6 L=1e-6
M10 net_4 out1fs source_nmos source_nmos nmos W=3e-6 L=1e-6
M11 out bias_n_1 net_4 net_4 nmos W=3e-6 L=1e-6
M12 net_5 insourcetc source_nmos source_nmos nmos W=1e-6 L=1e-6
M13 innercomp bias_n_1 net_5 net_5 nmos W=1e-6 L=1e-6
M14 innercomp instagebias source_pmos source_pmos pmos W=7e-6 L=1e-6
M15 bias_n_1 bias_n_1 source_nmos source_nmos nmos W=1e-6 L=1e-6
M16 ibias ibias source_pmos source_pmos pmos W=1e-6 L=1e-6
M17 bias_n_1 ibias source_pmos source_pmos pmos W=1e-6 L=1e-6
Cap_load_1 out source_nmos
.end symmetrical_op_amp_4189
