.suckt  2stage_pmos_input ibias in1 in2 out source_nmos source_pmos
M1 net_0 in1 net_1 net_1 pmos W=25e-6 L=1e-6
M2 net_2 in2 net_1 net_1 pmos W=25e-6 L=1e-6
M3 net_3 net_4 net_0 net_0 pmos W=25e-6 L=1e-6
M4 outfirststage net_4 net_2 net_2 pmos W=25e-6 L=1e-6
M5 net_3 net_3 source_nmos source_nmos nmos W=1e-6 L=2e-6
M6 outfirststage net_3 source_nmos source_nmos nmos W=1e-6 L=2e-6
M7 net_5 net_5 source_pmos source_pmos pmos W=1e-6 L=1e-6
M8 net_1 net_6 net_5 net_5 pmos W=1e-6 L=1e-6
M9 net_7 outfirststage source_pmos source_pmos pmos W=1e-6 L=2e-6
M10 out bias_p_3 net_7 net_7 pmos W=5e-6 L=2e-6
M11 out ibias source_nmos source_nmos nmos W=3e-6 L=2e-6
M12 ibias ibias source_nmos source_nmos nmos W=3e-6 L=2e-6
M13 net_4 net_4 net_1 net_1 pmos W=1e-6 L=3e-6
M14 net_6 net_6 bias_p_2m bias_p_2m pmos W=1e-6 L=1e-6
M15 bias_p_2m net_5 source_pmos source_pmos pmos W=1e-6 L=1e-6
M16 bias_p_3 bias_p_3 source_pmos source_pmos pmos W=1e-6 L=25e-6
M17 net_6 ibias source_nmos source_nmos nmos W=3e-6 L=2e-6
M18 net_4 ibias source_nmos source_nmos nmos W=3e-6 L=2e-6
M19 bias_p_3 ibias source_nmos source_nmos nmos W=3e-6 L=2e-6
Cap_load_1 out source_nmos
Cap_compensation_1 outfirststage out
.end 2stage_pmos_input
