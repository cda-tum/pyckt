.suckt  symmetrical_op_amp_4156 ibias in1 in2 out source_nmos source_pmos
M1 out1fs in1 net_0 net_0 nmos W=664e-6 L=1e-6
M2 out2fs in2 net_0 net_0 nmos W=664e-6 L=1e-6
M3 out1fs out1fs source_pmos source_pmos pmos W=1e-6 L=1e-6
M4 out2fs out2fs source_pmos source_pmos pmos W=1e-6 L=2e-6
M5 net_1 bias_n_1b source_nmos source_nmos nmos W=1e-6 L=1e-6
M6 net_0 ibias net_1 net_1 nmos W=1e-6 L=1e-6
M7 net_4 out1fs source_pmos source_pmos pmos W=1e-6 L=1e-6
M8 out bias_p_2 net_4 net_4 pmos W=17e-6 L=1e-6
M9 out instagebias source_nmos source_nmos nmos W=1e-6 L=1e-6
M10 net_5 out2fs source_pmos source_pmos pmos W=1e-6 L=2e-6
M11 instagebias bias_p_2 net_5 net_5 pmos W=1e-6 L=1e-6
M12 instagebias instagebias source_nmos source_nmos nmos W=1e-6 L=1e-6
M13 bias_n_1b bias_n_1b source_nmos source_nmos nmos W=1e-6 L=1e-6
M14 ibias ibias bias_n_1b bias_n_1b nmos W=1e-6 L=1e-6
M15 bias_p_2 bias_p_2 source_pmos source_pmos pmos W=1e-6 L=21e-6
M16 bias_p_2 bias_n_1b source_nmos source_nmos nmos W=1e-6 L=1e-6
Cap_load_1 out source_nmos
.end symmetrical_op_amp_4156
