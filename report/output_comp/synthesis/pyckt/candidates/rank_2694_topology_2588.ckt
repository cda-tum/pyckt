.suckt  1stage_pmos_input ibias in1 in2 out source_nmos source_pmos
M1 net_0 in1 net_1 net_1 pmos W=25e-6 L=1e-6
M2 out in2 net_1 net_1 pmos W=25e-6 L=1e-6
M3 net_2 net_0 source_pmos source_pmos pmos W=13e-6 L=2e-6
M4 net_0 bias_p_3 net_2 net_2 pmos W=13e-6 L=2e-6
M5 net_4 net_0 source_pmos source_pmos pmos W=13e-6 L=2e-6
M6 out bias_p_3 net_4 net_4 pmos W=13e-6 L=2e-6
M7 net_5 bias_n_1b source_nmos source_nmos nmos W=1e-6 L=2e-6
M8 net_0 ibias net_5 net_5 nmos W=1e-6 L=2e-6
M9 net_8 bias_n_1b source_nmos source_nmos nmos W=1e-6 L=2e-6
M10 out ibias net_8 net_8 nmos W=1e-6 L=2e-6
M11 net_9 net_9 source_pmos source_pmos pmos W=1e-6 L=1e-6
M12 net_1 net_10 net_9 net_9 pmos W=1e-6 L=1e-6
M13 bias_n_1b bias_n_1b source_nmos source_nmos nmos W=1e-6 L=2e-6
M14 ibias ibias bias_n_1b bias_n_1b nmos W=1e-6 L=2e-6
M15 net_10 net_10 bias_p_2m bias_p_2m pmos W=1e-6 L=1e-6
M16 bias_p_2m net_9 source_pmos source_pmos pmos W=1e-6 L=1e-6
M17 bias_p_3 bias_p_3 source_pmos source_pmos pmos W=1e-6 L=16e-6
M18 net_10 bias_n_1b source_nmos source_nmos nmos W=1e-6 L=2e-6
M19 bias_p_3 bias_n_1b source_nmos source_nmos nmos W=1e-6 L=2e-6
Cap_load_1 out source_nmos
.end 1stage_pmos_input
