.suckt  symmetrical_op_amp_4206 ibias in1 in2 out source_nmos source_pmos
M1 out1fs in1 net_0 net_0 nmos W=3e-6 L=1e-6
M2 insourcetc in2 net_0 net_0 nmos W=3e-6 L=1e-6
M3 net_1 out1fs source_pmos source_pmos pmos W=7e-6 L=1e-6
M4 out1fs bias_p_3 net_1 net_1 pmos W=7e-6 L=1e-6
M5 net_2 insourcetc source_pmos source_pmos pmos W=1e-6 L=1e-6
M6 insourcetc bias_p_3 net_2 net_2 pmos W=1e-6 L=1e-6
M7 net_0 ibias source_nmos source_nmos nmos W=1e-6 L=1e-6
M8 net_4 out1fs source_pmos source_pmos pmos W=7e-6 L=1e-6
M9 out bias_p_3 net_4 net_4 pmos W=7e-6 L=1e-6
M10 net_5 instagebias source_nmos source_nmos nmos W=1e-6 L=1e-6
M11 out bias_n_1 net_5 net_5 nmos W=2e-6 L=1e-6
M12 net_7 insourcetc source_pmos source_pmos pmos W=1e-6 L=1e-6
M13 instagebias bias_p_3 net_7 net_7 pmos W=1e-6 L=1e-6
M14 instagebias instagebias source_nmos source_nmos nmos W=1e-6 L=1e-6
M15 bias_n_1 bias_n_1 source_nmos source_nmos nmos W=1e-6 L=1e-6
M16 ibias ibias source_nmos source_nmos nmos W=1e-6 L=1e-6
M17 bias_p_3 bias_p_3 source_pmos source_pmos pmos W=1e-6 L=10e-6
M18 bias_p_4 bias_p_4 source_pmos source_pmos pmos W=1e-6 L=1e-6
M19 bias_n_1 bias_p_4 source_pmos source_pmos pmos W=1e-6 L=1e-6
M20 bias_p_3 ibias source_nmos source_nmos nmos W=1e-6 L=1e-6
M21 bias_p_4 ibias source_nmos source_nmos nmos W=1e-6 L=1e-6
Cap_load_1 out source_nmos
.end symmetrical_op_amp_4206
