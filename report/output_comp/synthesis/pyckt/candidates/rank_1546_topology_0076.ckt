.suckt  2stage_pmos_input ibias in1 in2 out source_nmos source_pmos
M1 net_0 in1 net_1 net_1 pmos W=15e-6 L=1e-6
M2 outfirststage in2 net_1 net_1 pmos W=15e-6 L=1e-6
M3 net_2 net_0 source_nmos source_nmos nmos W=1e-6 L=1e-6
M4 net_0 bias_n_1 net_2 net_2 nmos W=1e-6 L=1e-6
M5 net_4 net_0 source_nmos source_nmos nmos W=1e-6 L=1e-6
M6 outfirststage bias_n_1 net_4 net_4 nmos W=1e-6 L=1e-6
M7 net_1 ibias source_pmos source_pmos pmos W=1e-6 L=1e-6
M8 net_6 outfirststage source_pmos source_pmos pmos W=1e-6 L=3e-6
M9 out bias_p_3 net_6 net_6 pmos W=6e-6 L=3e-6
M10 out bias_n_2 source_nmos source_nmos nmos W=4e-6 L=3e-6
M11 bias_n_1 bias_n_1 source_nmos source_nmos nmos W=1e-6 L=1e-6
M12 bias_n_2 bias_n_2 source_nmos source_nmos nmos W=4e-6 L=3e-6
M13 bias_p_3 bias_p_3 source_pmos source_pmos pmos W=1e-6 L=19e-6
M14 ibias ibias source_pmos source_pmos pmos W=1e-6 L=1e-6
M15 bias_n_2 ibias source_pmos source_pmos pmos W=1e-6 L=1e-6
M16 bias_n_1 ibias source_pmos source_pmos pmos W=1e-6 L=1e-6
M17 bias_p_3 bias_n_2 source_nmos source_nmos nmos W=4e-6 L=3e-6
Cap_load_1 out source_nmos
Cap_compensation_1 outfirststage out
.end 2stage_pmos_input
