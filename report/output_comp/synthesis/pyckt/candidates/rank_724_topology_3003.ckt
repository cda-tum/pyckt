.suckt  2stage_nmos_input ibias in1 in2 out source_nmos source_pmos
M1 net_0 in1 net_1 net_1 nmos W=22e-6 L=1e-6
M2 outfirststage in2 net_1 net_1 nmos W=22e-6 L=1e-6
M3 net_2 net_0 source_nmos source_nmos nmos W=1e-6 L=1e-6
M4 net_0 bias_n_2 net_2 net_2 nmos W=1e-6 L=1e-6
M5 net_4 net_0 source_nmos source_nmos nmos W=1e-6 L=1e-6
M6 outfirststage bias_n_2 net_4 net_4 nmos W=1e-6 L=1e-6
M7 net_5 ibias source_pmos source_pmos pmos W=1e-6 L=1e-6
M8 net_0 bias_p_4 net_5 net_5 pmos W=1e-6 L=2e-6
M9 net_8 ibias source_pmos source_pmos pmos W=1e-6 L=1e-6
M10 outfirststage bias_p_4 net_8 net_8 pmos W=1e-6 L=1e-6
M11 net_9 bias_n_3 source_nmos source_nmos nmos W=1e-6 L=1e-6
M12 net_1 bias_n_2 net_9 net_9 nmos W=1e-6 L=1e-6
M13 net_12 outfirststage source_pmos source_pmos pmos W=1e-6 L=1e-6
M14 out bias_p_4 net_12 net_12 pmos W=7e-6 L=1e-6
M15 net_14 net_14 source_nmos source_nmos nmos W=2e-6 L=1e-6
M16 out net_15 net_14 net_14 nmos W=2e-6 L=1e-6
M17 net_15 net_15 bias_n_1m bias_n_1m nmos W=2e-6 L=1e-6
M18 bias_n_1m net_14 source_nmos source_nmos nmos W=2e-6 L=1e-6
M19 bias_n_2 bias_n_2 source_nmos source_nmos nmos W=1e-6 L=1e-6
M20 bias_n_3 bias_n_3 source_nmos source_nmos nmos W=1e-6 L=1e-6
M21 bias_p_4 bias_p_4 source_pmos source_pmos pmos W=1e-6 L=7e-6
M22 ibias ibias source_pmos source_pmos pmos W=1e-6 L=1e-6
M23 bias_n_3 ibias source_pmos source_pmos pmos W=1e-6 L=1e-6
M24 bias_n_2 ibias source_pmos source_pmos pmos W=1e-6 L=1e-6
M25 bias_p_4 bias_n_3 source_nmos source_nmos nmos W=1e-6 L=1e-6
M26 net_15 ibias source_pmos source_pmos pmos W=1e-6 L=1e-6
Cap_load_1 out source_nmos
Cap_compensation_1 outfirststage out
.end 2stage_nmos_input
