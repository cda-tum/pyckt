.suckt  2stage_pmos_input ibias in1 in2 out source_nmos source_pmos
M1 net_0 in1 net_1 net_1 pmos W=102e-6 L=1e-6
M2 net_2 in2 net_1 net_1 pmos W=102e-6 L=1e-6
M3 net_3 net_4 net_0 net_0 pmos W=102e-6 L=1e-6
M4 outfirststage net_4 net_2 net_2 pmos W=102e-6 L=1e-6
M5 net_5 net_3 source_nmos source_nmos nmos W=1e-6 L=1e-6
M6 net_3 bias_n_1 net_5 net_5 nmos W=1e-6 L=1e-6
M7 net_7 net_3 source_nmos source_nmos nmos W=1e-6 L=1e-6
M8 outfirststage bias_n_1 net_7 net_7 nmos W=1e-6 L=1e-6
M9 net_8 bias_p_4 source_pmos source_pmos pmos W=1e-6 L=3e-6
M10 net_1 bias_p_3 net_8 net_8 pmos W=1e-6 L=1e-6
M11 net_11 outfirststage source_pmos source_pmos pmos W=1e-6 L=1e-6
M12 out bias_p_3 net_11 net_11 pmos W=78e-6 L=1e-6
M13 net_13 ibias source_nmos source_nmos nmos W=1e-6 L=1e-6
M14 out bias_n_1 net_13 net_13 nmos W=2e-6 L=1e-6
M15 bias_n_1 bias_n_1 source_nmos source_nmos nmos W=1e-6 L=1e-6
M16 ibias ibias source_nmos source_nmos nmos W=1e-6 L=1e-6
M17 net_4 net_4 net_1 net_1 pmos W=1e-6 L=1e-6
M18 bias_p_3 bias_p_3 source_pmos source_pmos pmos W=1e-6 L=15e-6
M19 bias_p_4 bias_p_4 source_pmos source_pmos pmos W=1e-6 L=3e-6
M20 bias_p_4 ibias source_nmos source_nmos nmos W=1e-6 L=1e-6
M21 bias_n_1 bias_p_4 source_pmos source_pmos pmos W=1e-6 L=3e-6
M22 net_4 ibias source_nmos source_nmos nmos W=1e-6 L=1e-6
M23 bias_p_3 ibias source_nmos source_nmos nmos W=1e-6 L=1e-6
Cap_load_1 out source_nmos
Cap_compensation_1 outfirststage out
.end 2stage_pmos_input
