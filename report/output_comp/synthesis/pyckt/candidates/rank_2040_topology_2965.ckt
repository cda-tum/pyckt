.suckt  1stage_nmos_input ibias in1 in2 out source_nmos source_pmos
M1 net_0 in1 net_1 net_1 nmos W=106e-6 L=1e-6
M2 out in2 net_1 net_1 nmos W=106e-6 L=1e-6
M3 net_2 net_0 source_nmos source_nmos nmos W=12e-6 L=1e-6
M4 net_0 bias_n_1 net_2 net_2 nmos W=12e-6 L=1e-6
M5 net_4 net_0 source_nmos source_nmos nmos W=12e-6 L=1e-6
M6 out bias_n_1 net_4 net_4 nmos W=12e-6 L=1e-6
M7 net_0 ibias source_pmos source_pmos pmos W=1e-6 L=1e-6
M8 out ibias source_pmos source_pmos pmos W=1e-6 L=1e-6
M9 net_6 bias_n_2 source_nmos source_nmos nmos W=1e-6 L=1e-6
M10 net_1 bias_n_1 net_6 net_6 nmos W=2e-6 L=1e-6
M11 bias_n_1 bias_n_1 source_nmos source_nmos nmos W=1e-6 L=1e-6
M12 bias_n_2 bias_n_2 source_nmos source_nmos nmos W=1e-6 L=1e-6
M13 ibias ibias source_pmos source_pmos pmos W=1e-6 L=1e-6
M14 bias_n_2 ibias source_pmos source_pmos pmos W=1e-6 L=1e-6
M15 bias_n_1 ibias source_pmos source_pmos pmos W=1e-6 L=1e-6
Cap_load_1 out source_nmos
.end 1stage_nmos_input
