.suckt  symmetrical_op_amp_4110 ibias in1 in2 out source_nmos source_pmos
M1 out1fs in1 net_0 net_0 nmos W=983e-6 L=1e-6
M2 out2fs in2 net_0 net_0 nmos W=983e-6 L=1e-6
M3 out1fs out1fs source_pmos source_pmos pmos W=1e-6 L=1e-6
M4 out2fs out2fs source_pmos source_pmos pmos W=1e-6 L=1e-6
M5 net_0 ibias source_nmos source_nmos nmos W=1e-6 L=1e-6
M6 out out1fs source_pmos source_pmos pmos W=1e-6 L=1e-6
M7 net_2 insourcestagebias source_nmos source_nmos nmos W=33e-6 L=1e-6
M8 out bias_n_1 net_2 net_2 nmos W=33e-6 L=1e-6
M9 insourcestagebias out2fs source_pmos source_pmos pmos W=1e-6 L=1e-6
M10 net_3 insourcestagebias source_nmos source_nmos nmos W=33e-6 L=1e-6
M11 insourcestagebias bias_n_1 net_3 net_3 nmos W=33e-6 L=1e-6
M12 bias_n_1 bias_n_1 source_nmos source_nmos nmos W=3e-6 L=1e-6
M13 ibias ibias source_nmos source_nmos nmos W=1e-6 L=1e-6
M14 bias_p_3 bias_p_3 source_pmos source_pmos pmos W=1e-6 L=1e-6
M15 bias_n_1 bias_p_3 source_pmos source_pmos pmos W=1e-6 L=1e-6
M16 bias_p_3 ibias source_nmos source_nmos nmos W=1e-6 L=1e-6
Cap_load_1 out source_nmos
.end symmetrical_op_amp_4110
