.suckt  2stage_nmos_input ibias in1 in2 out source_nmos source_pmos
M1 net_0 in1 net_1 net_1 nmos W=4e-6 L=1e-6
M2 outfirststage in2 net_1 net_1 nmos W=4e-6 L=1e-6
M3 net_2 net_3 source_pmos source_pmos pmos W=1e-6 L=1e-6
M4 net_0 net_0 net_2 net_2 pmos W=1e-6 L=1e-6
M5 net_3 net_3 source_pmos source_pmos pmos W=1e-6 L=1e-6
M6 outfirststage net_0 net_3 net_3 pmos W=1e-6 L=1e-6
M7 net_4 bias_n_2b source_nmos source_nmos nmos W=1e-6 L=1e-6
M8 net_1 ibias net_4 net_4 nmos W=1e-6 L=1e-6
M9 net_7 outfirststage source_pmos source_pmos pmos W=1e-6 L=1e-6
M10 out bias_p_3 net_7 net_7 pmos W=7e-6 L=1e-6
M11 net_9 net_9 source_nmos source_nmos nmos W=2e-6 L=1e-6
M12 out net_10 net_9 net_9 nmos W=2e-6 L=1e-6
M13 net_10 net_10 bias_n_1m bias_n_1m nmos W=2e-6 L=1e-6
M14 bias_n_1m net_9 source_nmos source_nmos nmos W=2e-6 L=1e-6
M15 bias_n_2b bias_n_2b source_nmos source_nmos nmos W=1e-6 L=1e-6
M16 ibias ibias bias_n_2b bias_n_2b nmos W=1e-6 L=1e-6
M17 bias_p_3 bias_p_3 source_pmos source_pmos pmos W=1e-6 L=9e-6
M18 bias_p_4 bias_p_4 source_pmos source_pmos pmos W=1e-6 L=1e-6
M19 bias_p_3 bias_n_2b source_nmos source_nmos nmos W=1e-6 L=1e-6
M20 net_10 bias_p_4 source_pmos source_pmos pmos W=1e-6 L=1e-6
M21 bias_p_4 bias_n_2b source_nmos source_nmos nmos W=1e-6 L=1e-6
Cap_load_1 out source_nmos
Cap_compensation_1 outfirststage out
.end 2stage_nmos_input
