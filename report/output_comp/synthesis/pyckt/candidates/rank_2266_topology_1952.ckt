.suckt  2stage_pmos_input ibias in1 in2 out source_nmos source_pmos
M1 net_0 in1 net_1 net_1 pmos W=30e-6 L=1e-6
M2 outfirststage in2 net_1 net_1 pmos W=30e-6 L=1e-6
M3 net_0 net_0 source_pmos source_pmos pmos W=1e-6 L=5e-6
M4 net_2 net_0 source_pmos source_pmos pmos W=1e-6 L=5e-6
M5 outfirststage bias_p_2 net_2 net_2 pmos W=1e-6 L=5e-6
M6 net_0 ibias source_nmos source_nmos nmos W=1e-6 L=5e-6
M7 outfirststage ibias source_nmos source_nmos nmos W=1e-6 L=5e-6
M8 net_1 bias_p_3 source_pmos source_pmos pmos W=6e-6 L=1e-6
M9 out bias_p_3 source_pmos source_pmos pmos W=6e-6 L=1e-6
M10 out outfirststage source_nmos source_nmos nmos W=2e-6 L=1e-6
M11 ibias ibias source_nmos source_nmos nmos W=1e-6 L=5e-6
M12 bias_p_2 bias_p_2 source_pmos source_pmos pmos W=1e-6 L=15e-6
M13 bias_p_3 bias_p_3 source_pmos source_pmos pmos W=6e-6 L=1e-6
M14 bias_p_3 ibias source_nmos source_nmos nmos W=1e-6 L=5e-6
M15 bias_p_2 ibias source_nmos source_nmos nmos W=1e-6 L=5e-6
Cap_load_1 out source_nmos
Cap_compensation_1 outfirststage out
.end 2stage_pmos_input
