.suckt  2stage_nmos_input ibias in1 in2 out source_nmos source_pmos
M1 net_0 in1 net_1 net_1 nmos W=9e-6 L=1e-6
M2 outfirststage in2 net_1 net_1 nmos W=9e-6 L=1e-6
M3 net_0 net_0 source_pmos source_pmos pmos W=1e-6 L=3e-6
M4 outfirststage net_0 source_pmos source_pmos pmos W=1e-6 L=3e-6
M5 net_2 bias_n_1b source_nmos source_nmos nmos W=3e-6 L=1e-6
M6 net_1 ibias net_2 net_2 nmos W=3e-6 L=1e-6
M7 net_5 outfirststage source_pmos source_pmos pmos W=1e-6 L=1e-6
M8 out bias_p_2 net_5 net_5 pmos W=10e-6 L=1e-6
M9 net_7 bias_n_1b source_nmos source_nmos nmos W=3e-6 L=1e-6
M10 out ibias net_7 net_7 nmos W=3e-6 L=1e-6
M11 bias_n_1b bias_n_1b source_nmos source_nmos nmos W=3e-6 L=1e-6
M12 ibias ibias bias_n_1b bias_n_1b nmos W=3e-6 L=1e-6
M13 bias_p_2 bias_p_2 source_pmos source_pmos pmos W=1e-6 L=3e-6
M14 bias_p_2 bias_n_1b source_nmos source_nmos nmos W=3e-6 L=1e-6
Cap_load_1 out source_nmos
Cap_compensation_1 outfirststage out
.end 2stage_nmos_input
