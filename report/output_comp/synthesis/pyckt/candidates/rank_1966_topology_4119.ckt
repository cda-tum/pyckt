.suckt  symmetrical_op_amp_4119 ibias in1 in2 out source_nmos source_pmos
M1 out1fs in1 net_0 net_0 nmos W=4e-6 L=1e-6
M2 out2fs in2 net_0 net_0 nmos W=4e-6 L=1e-6
M3 out1fs out1fs source_pmos source_pmos pmos W=1e-6 L=1e-6
M4 out2fs out2fs source_pmos source_pmos pmos W=1e-6 L=1e-6
M5 net_0 ibias source_nmos source_nmos nmos W=1e-6 L=1e-6
M6 net_2 out1fs source_pmos source_pmos pmos W=1e-6 L=1e-6
M7 out bias_p_2 net_2 net_2 pmos W=7e-6 L=1e-6
M8 instagebias instagebias source_nmos source_nmos nmos W=2e-6 L=1e-6
M9 out innercomp instagebias instagebias nmos W=2e-6 L=1e-6
M10 net_3 out2fs source_pmos source_pmos pmos W=1e-6 L=1e-6
M11 innercomp bias_p_2 net_3 net_3 pmos W=1e-6 L=1e-6
M12 innercomp instagebias source_nmos source_nmos nmos W=2e-6 L=1e-6
M13 ibias ibias source_nmos source_nmos nmos W=1e-6 L=1e-6
M14 bias_p_2 bias_p_2 source_pmos source_pmos pmos W=1e-6 L=16e-6
M15 bias_p_2 ibias source_nmos source_nmos nmos W=1e-6 L=1e-6
Cap_load_1 out source_nmos
.end symmetrical_op_amp_4119
