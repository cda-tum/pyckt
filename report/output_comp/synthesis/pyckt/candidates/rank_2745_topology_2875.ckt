.suckt  2stage_nmos_input ibias in1 in2 out source_nmos source_pmos
M1 net_0 in1 net_1 net_1 nmos W=7e-6 L=1e-6
M2 outfirststage in2 net_1 net_1 nmos W=7e-6 L=1e-6
M3 net_0 net_0 source_nmos source_nmos nmos W=1e-6 L=1e-6
M4 net_2 net_0 source_nmos source_nmos nmos W=1e-6 L=1e-6
M5 outfirststage bias_n_2 net_2 net_2 nmos W=1e-6 L=1e-6
M6 net_0 ibias source_pmos source_pmos pmos W=1e-6 L=1e-6
M7 outfirststage ibias source_pmos source_pmos pmos W=1e-6 L=1e-6
M8 net_5 net_5 source_nmos source_nmos nmos W=1e-6 L=1e-6
M9 net_1 net_6 net_5 net_5 nmos W=1e-6 L=1e-6
M10 out ibias source_pmos source_pmos pmos W=1e-6 L=1e-6
M11 out outfirststage source_nmos source_nmos nmos W=2e-6 L=1e-6
M12 net_6 net_6 bias_n_1m bias_n_1m nmos W=1e-6 L=1e-6
M13 bias_n_1m net_5 source_nmos source_nmos nmos W=1e-6 L=1e-6
M14 bias_n_2 bias_n_2 source_nmos source_nmos nmos W=1e-6 L=1e-6
M15 ibias ibias source_pmos source_pmos pmos W=1e-6 L=1e-6
M16 net_6 ibias source_pmos source_pmos pmos W=1e-6 L=1e-6
M17 bias_n_2 ibias source_pmos source_pmos pmos W=1e-6 L=1e-6
Cap_load_1 out source_nmos
Cap_compensation_1 outfirststage out
.end 2stage_nmos_input
