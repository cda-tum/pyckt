.suckt  symmetrical_op_amp_4143 ibias in1 in2 out source_nmos source_pmos
M1 out1fs in1 net_0 net_0 pmos W=25e-6 L=1e-6
M2 out2fs in2 net_0 net_0 pmos W=25e-6 L=1e-6
M3 out1fs out1fs source_nmos source_nmos nmos W=1e-6 L=1e-6
M4 out2fs out2fs source_nmos source_nmos nmos W=1e-6 L=1e-6
M5 net_1 net_1 source_pmos source_pmos pmos W=1e-6 L=1e-6
M6 net_0 ibias net_1 net_1 pmos W=1e-6 L=1e-6
M7 net_3 insourcestagebias source_pmos source_pmos pmos W=7e-6 L=1e-6
M8 out bias_p_3 net_3 net_3 pmos W=7e-6 L=1e-6
M9 net_4 out1fs source_nmos source_nmos nmos W=1e-6 L=1e-6
M10 out bias_n_1 net_4 net_4 nmos W=2e-6 L=1e-6
M11 net_5 out2fs source_nmos source_nmos nmos W=1e-6 L=1e-6
M12 insourcestagebias bias_n_1 net_5 net_5 nmos W=1e-6 L=1e-6
M13 net_6 insourcestagebias source_pmos source_pmos pmos W=7e-6 L=1e-6
M14 insourcestagebias bias_p_3 net_6 net_6 pmos W=7e-6 L=1e-6
M15 bias_n_1 bias_n_1 source_nmos source_nmos nmos W=1e-6 L=1e-6
M16 ibias ibias bias_p_2m bias_p_2m pmos W=1e-6 L=1e-6
M17 bias_p_2m net_1 source_pmos source_pmos pmos W=1e-6 L=1e-6
M18 bias_p_3 bias_p_3 source_pmos source_pmos pmos W=1e-6 L=6e-6
M19 bias_n_4 bias_n_4 source_nmos source_nmos nmos W=1e-6 L=1e-6
M20 bias_n_1 net_1 source_pmos source_pmos pmos W=1e-6 L=1e-6
M21 bias_p_3 bias_n_4 source_nmos source_nmos nmos W=1e-6 L=1e-6
M22 bias_n_4 net_1 source_pmos source_pmos pmos W=1e-6 L=1e-6
Cap_load_1 out source_nmos
.end symmetrical_op_amp_4143
