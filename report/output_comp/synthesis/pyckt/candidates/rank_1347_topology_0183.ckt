.suckt  1stage_nmos_input ibias in1 in2 out source_nmos source_pmos
M1 net_0 in1 net_1 net_1 nmos W=4e-6 L=1e-6
M2 out in2 net_1 net_1 nmos W=4e-6 L=1e-6
M3 net_2 net_3 source_pmos source_pmos pmos W=1e-6 L=1e-6
M4 net_0 net_0 net_2 net_2 pmos W=1e-6 L=1e-6
M5 net_3 net_3 source_pmos source_pmos pmos W=1e-6 L=1e-6
M6 out net_0 net_3 net_3 pmos W=1e-6 L=1e-6
M7 net_1 ibias source_nmos source_nmos nmos W=1e-6 L=1e-6
M8 ibias ibias source_nmos source_nmos nmos W=1e-6 L=1e-6
Cap_load_1 out source_nmos
.end 1stage_nmos_input
