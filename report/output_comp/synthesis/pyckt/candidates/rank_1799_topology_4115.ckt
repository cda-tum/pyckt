.suckt  symmetrical_op_amp_4115 ibias in1 in2 out source_nmos source_pmos
M1 out1fs in1 net_0 net_0 nmos W=4e-6 L=1e-6
M2 out2fs in2 net_0 net_0 nmos W=4e-6 L=1e-6
M3 out1fs out1fs source_pmos source_pmos pmos W=1e-6 L=1e-6
M4 out2fs out2fs source_pmos source_pmos pmos W=1e-6 L=1e-6
M5 net_0 ibias source_nmos source_nmos nmos W=1e-6 L=1e-6
M6 net_2 out1fs source_pmos source_pmos pmos W=1e-6 L=1e-6
M7 out bias_p_3 net_2 net_2 pmos W=6e-6 L=1e-6
M8 net_3 instagebias source_nmos source_nmos nmos W=1e-6 L=1e-6
M9 out bias_n_1 net_3 net_3 nmos W=2e-6 L=1e-6
M10 net_5 out2fs source_pmos source_pmos pmos W=1e-6 L=1e-6
M11 instagebias bias_p_3 net_5 net_5 pmos W=1e-6 L=1e-6
M12 instagebias instagebias source_nmos source_nmos nmos W=1e-6 L=1e-6
M13 bias_n_1 bias_n_1 source_nmos source_nmos nmos W=1e-6 L=1e-6
M14 ibias ibias source_nmos source_nmos nmos W=1e-6 L=1e-6
M15 bias_p_3 bias_p_3 source_pmos source_pmos pmos W=1e-6 L=13e-6
M16 bias_p_4 bias_p_4 source_pmos source_pmos pmos W=1e-6 L=2e-6
M17 bias_n_1 bias_p_4 source_pmos source_pmos pmos W=1e-6 L=2e-6
M18 bias_p_3 ibias source_nmos source_nmos nmos W=1e-6 L=1e-6
M19 bias_p_4 ibias source_nmos source_nmos nmos W=1e-6 L=1e-6
Cap_load_1 out source_nmos
.end symmetrical_op_amp_4115
