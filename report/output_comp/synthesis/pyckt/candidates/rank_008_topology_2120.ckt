.suckt  1stage_nmos_input ibias in1 in2 out source_nmos source_pmos
M1 net_0 in1 net_1 net_1 nmos W=667e-6 L=1e-6
M2 out in2 net_1 net_1 nmos W=667e-6 L=1e-6
M3 net_0 net_0 source_nmos source_nmos nmos W=1e-6 L=7e-6
M4 out net_0 source_nmos source_nmos nmos W=1e-6 L=7e-6
M5 net_2 bias_p_2b source_pmos source_pmos pmos W=4e-6 L=7e-6
M6 net_0 bias_p_2t net_2 net_2 pmos W=4e-6 L=7e-6
M7 net_5 bias_p_2b source_pmos source_pmos pmos W=4e-6 L=7e-6
M8 out bias_p_2t net_5 net_5 pmos W=4e-6 L=7e-6
M9 net_1 ibias source_nmos source_nmos nmos W=1e-6 L=1e-6
M10 ibias ibias source_nmos source_nmos nmos W=1e-6 L=1e-6
M11 bias_p_2b bias_p_2b source_pmos source_pmos pmos W=4e-6 L=7e-6
M12 bias_p_2t bias_p_2t bias_p_2b bias_p_2b pmos W=4e-6 L=7e-6
M13 bias_p_2t ibias source_nmos source_nmos nmos W=1e-6 L=1e-6
Cap_load_1 out source_nmos
.end 1stage_nmos_input
