.suckt  1stage_nmos_input ibias in1 in2 out source_nmos source_pmos
M1 net_0 in1 net_1 net_1 nmos W=1000e-6 L=1e-6
M2 out in2 net_1 net_1 nmos W=1000e-6 L=1e-6
M3 net_0 net_0 source_nmos source_nmos nmos W=1e-6 L=7e-6
M4 out net_0 source_nmos source_nmos nmos W=1e-6 L=7e-6
M5 net_0 bias_p_2 source_pmos source_pmos pmos W=2e-6 L=1e-6
M6 out bias_p_2 source_pmos source_pmos pmos W=2e-6 L=1e-6
M7 net_1 ibias source_nmos source_nmos nmos W=1e-6 L=1e-6
M8 ibias ibias source_nmos source_nmos nmos W=1e-6 L=1e-6
M9 bias_p_2 bias_p_2 source_pmos source_pmos pmos W=2e-6 L=1e-6
M10 bias_p_2 ibias source_nmos source_nmos nmos W=1e-6 L=1e-6
Cap_load_1 out source_nmos
.end 1stage_nmos_input
