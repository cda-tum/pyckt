.suckt  symmetrical_op_amp_4164 ibias in1 in2 out source_nmos source_pmos
M1 out1fs in1 net_0 net_0 nmos W=970e-6 L=1e-6
M2 out2fs in2 net_0 net_0 nmos W=970e-6 L=1e-6
M3 out1fs out1fs source_pmos source_pmos pmos W=5e-6 L=1e-6
M4 out2fs out2fs source_pmos source_pmos pmos W=1e-6 L=1e-6
M5 net_1 net_1 source_nmos source_nmos nmos W=1e-6 L=1e-6
M6 net_0 ibias net_1 net_1 nmos W=1e-6 L=1e-6
M7 out out1fs source_pmos source_pmos pmos W=5e-6 L=1e-6
M8 net_3 instagebias source_nmos source_nmos nmos W=1e-6 L=1e-6
M9 out bias_n_2 net_3 net_3 nmos W=2e-6 L=1e-6
M10 instagebias out2fs source_pmos source_pmos pmos W=1e-6 L=1e-6
M11 instagebias instagebias source_nmos source_nmos nmos W=1e-6 L=1e-6
M12 ibias ibias bias_n_1m bias_n_1m nmos W=1e-6 L=1e-6
M13 bias_n_1m net_1 source_nmos source_nmos nmos W=1e-6 L=1e-6
M14 bias_n_2 bias_n_2 source_nmos source_nmos nmos W=1e-6 L=1e-6
M15 bias_p_3 bias_p_3 source_pmos source_pmos pmos W=1e-6 L=1e-6
M16 bias_n_2 bias_p_3 source_pmos source_pmos pmos W=1e-6 L=1e-6
M17 bias_p_3 net_1 source_nmos source_nmos nmos W=1e-6 L=1e-6
Cap_load_1 out source_nmos
.end symmetrical_op_amp_4164
