.suckt  2stage_nmos_input ibias in1 in2 out source_nmos source_pmos
M1 net_0 in1 net_1 net_1 nmos W=12e-6 L=1e-6
M2 outfirststage in2 net_1 net_1 nmos W=12e-6 L=1e-6
M3 net_0 net_0 source_pmos source_pmos pmos W=1e-6 L=1e-6
M4 outfirststage net_0 source_pmos source_pmos pmos W=1e-6 L=1e-6
M5 net_2 bias_n_1b source_nmos source_nmos nmos W=3e-6 L=1e-6
M6 net_1 ibias net_2 net_2 nmos W=3e-6 L=1e-6
M7 out outfirststage source_pmos source_pmos pmos W=1e-6 L=1e-6
M8 net_5 bias_n_1b source_nmos source_nmos nmos W=3e-6 L=1e-6
M9 out ibias net_5 net_5 nmos W=3e-6 L=1e-6
M10 bias_n_1b bias_n_1b source_nmos source_nmos nmos W=3e-6 L=1e-6
M11 ibias ibias bias_n_1b bias_n_1b nmos W=3e-6 L=1e-6
Cap_load_1 out source_nmos
Cap_compensation_1 outfirststage out
.end 2stage_nmos_input
