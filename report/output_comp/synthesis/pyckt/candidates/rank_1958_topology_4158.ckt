.suckt  symmetrical_op_amp_4158 ibias in1 in2 out source_nmos source_pmos
M1 out1fs in1 net_0 net_0 nmos W=4e-6 L=1e-6
M2 out2fs in2 net_0 net_0 nmos W=4e-6 L=1e-6
M3 out1fs out1fs source_pmos source_pmos pmos W=1e-6 L=1e-6
M4 out2fs out2fs source_pmos source_pmos pmos W=1e-6 L=1e-6
M5 net_1 bias_n_1b source_nmos source_nmos nmos W=1e-6 L=1e-6
M6 net_0 ibias net_1 net_1 nmos W=1e-6 L=1e-6
M7 net_4 out1fs source_pmos source_pmos pmos W=1e-6 L=1e-6
M8 out bias_p_2 net_4 net_4 pmos W=7e-6 L=1e-6
M9 net_5 insourcestagebias source_nmos source_nmos nmos W=2e-6 L=1e-6
M10 out inoutputstagebias net_5 net_5 nmos W=2e-6 L=1e-6
M11 net_6 out2fs source_pmos source_pmos pmos W=1e-6 L=1e-6
M12 inoutputstagebias bias_p_2 net_6 net_6 pmos W=1e-6 L=1e-6
M13 insourcestagebias insourcestagebias source_nmos source_nmos nmos W=2e-6 L=1e-6
M14 inoutputstagebias inoutputstagebias insourcestagebias insourcestagebias nmos W=2e-6 L=1e-6
M15 bias_n_1b bias_n_1b source_nmos source_nmos nmos W=1e-6 L=1e-6
M16 ibias ibias bias_n_1b bias_n_1b nmos W=1e-6 L=1e-6
M17 bias_p_2 bias_p_2 source_pmos source_pmos pmos W=1e-6 L=12e-6
M18 bias_p_2 bias_n_1b source_nmos source_nmos nmos W=1e-6 L=1e-6
Cap_load_1 out source_nmos
.end symmetrical_op_amp_4158
