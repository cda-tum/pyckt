.suckt  1stage_pmos_input ibias in1 in2 out source_nmos source_pmos
M1 net_0 in1 net_1 net_1 pmos W=999e-6 L=1e-6
M2 out in2 net_1 net_1 pmos W=999e-6 L=1e-6
M3 net_2 net_2 source_pmos source_pmos pmos W=1e-6 L=1e-6
M4 net_0 net_0 net_2 net_2 pmos W=1e-6 L=1e-6
M5 net_3 net_2 source_pmos source_pmos pmos W=1e-6 L=1e-6
M6 out net_0 net_3 net_3 pmos W=1e-6 L=1e-6
M7 net_0 bias_n_1 source_nmos source_nmos nmos W=1e-6 L=1e-6
M8 out bias_n_1 source_nmos source_nmos nmos W=1e-6 L=1e-6
M9 net_1 ibias source_pmos source_pmos pmos W=1e-6 L=1e-6
M10 bias_n_1 bias_n_1 source_nmos source_nmos nmos W=1e-6 L=1e-6
M11 ibias ibias source_pmos source_pmos pmos W=1e-6 L=1e-6
M12 bias_n_1 ibias source_pmos source_pmos pmos W=1e-6 L=1e-6
Cap_load_1 out source_nmos
.end 1stage_pmos_input
