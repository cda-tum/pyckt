.suckt  2stage_pmos_input ibias in1 in2 out source_nmos source_pmos
M1 net_0 in1 net_1 net_1 pmos W=21e-6 L=1e-6
M2 net_2 in2 net_1 net_1 pmos W=21e-6 L=1e-6
M3 net_0 bias_n_2b source_nmos source_nmos nmos W=21e-6 L=1e-6
M4 net_4 bias_n_2t net_0 net_0 nmos W=21e-6 L=1e-6
M5 net_2 bias_n_2b source_nmos source_nmos nmos W=21e-6 L=1e-6
M6 outfirststage bias_n_2t net_2 net_2 nmos W=21e-6 L=1e-6
M7 net_4 net_4 source_pmos source_pmos pmos W=1e-6 L=1e-6
M8 outfirststage net_4 source_pmos source_pmos pmos W=1e-6 L=1e-6
M9 net_6 ibias source_pmos source_pmos pmos W=1e-6 L=2e-6
M10 net_1 bias_p_3 net_6 net_6 pmos W=1e-6 L=1e-6
M11 net_9 outfirststage source_pmos source_pmos pmos W=1e-6 L=1e-6
M12 out bias_p_3 net_9 net_9 pmos W=8e-6 L=1e-6
M13 net_11 net_11 source_nmos source_nmos nmos W=2e-6 L=1e-6
M14 out net_12 net_11 net_11 nmos W=2e-6 L=1e-6
M15 net_12 net_12 bias_n_1m bias_n_1m nmos W=2e-6 L=1e-6
M16 bias_n_1m net_11 source_nmos source_nmos nmos W=2e-6 L=1e-6
M17 bias_n_2b bias_n_2b source_nmos source_nmos nmos W=21e-6 L=1e-6
M18 bias_n_2t bias_n_2t bias_n_2b bias_n_2b nmos W=21e-6 L=1e-6
M19 bias_p_3 bias_p_3 source_pmos source_pmos pmos W=1e-6 L=8e-6
M20 ibias ibias source_pmos source_pmos pmos W=1e-6 L=2e-6
M21 bias_n_2t ibias source_pmos source_pmos pmos W=1e-6 L=2e-6
M22 bias_p_3 bias_n_2b source_nmos source_nmos nmos W=21e-6 L=1e-6
M23 net_12 ibias source_pmos source_pmos pmos W=1e-6 L=2e-6
Cap_load_1 out source_nmos
Cap_compensation_1 outfirststage out
.end 2stage_pmos_input
