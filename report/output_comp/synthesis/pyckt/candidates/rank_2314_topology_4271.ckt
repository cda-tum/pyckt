.suckt  symmetrical_op_amp_4271 ibias in1 in2 out source_nmos source_pmos
M1 out2fs in1 net_0 net_0 nmos W=4e-6 L=1e-6
M2 inoutputtc in2 net_0 net_0 nmos W=4e-6 L=1e-6
M3 out1fs out1fs source_pmos source_pmos pmos W=6e-6 L=1e-6
M4 out2fs out2fs out1fs out1fs pmos W=6e-6 L=1e-6
M5 insourcetc insourcetc source_pmos source_pmos pmos W=1e-6 L=3e-6
M6 inoutputtc inoutputtc insourcetc insourcetc pmos W=1e-6 L=3e-6
M7 net_1 net_1 source_nmos source_nmos nmos W=1e-6 L=1e-6
M8 net_0 ibias net_1 net_1 nmos W=1e-6 L=1e-6
M9 net_3 out1fs source_pmos source_pmos pmos W=6e-6 L=1e-6
M10 out out2fs net_3 net_3 pmos W=6e-6 L=1e-6
M11 net_4 insourcestagebias source_nmos source_nmos nmos W=5e-6 L=1e-6
M12 out bias_n_2 net_4 net_4 nmos W=5e-6 L=1e-6
M13 net_5 insourcetc source_pmos source_pmos pmos W=1e-6 L=3e-6
M14 insourcestagebias inoutputtc net_5 net_5 pmos W=1e-6 L=3e-6
M15 net_6 insourcestagebias source_nmos source_nmos nmos W=5e-6 L=1e-6
M16 insourcestagebias bias_n_2 net_6 net_6 nmos W=5e-6 L=1e-6
M17 ibias ibias bias_n_1m bias_n_1m nmos W=1e-6 L=1e-6
M18 bias_n_1m net_1 source_nmos source_nmos nmos W=1e-6 L=1e-6
M19 bias_n_2 bias_n_2 source_nmos source_nmos nmos W=1e-6 L=1e-6
M20 bias_p_3 bias_p_3 source_pmos source_pmos pmos W=1e-6 L=1e-6
M21 bias_n_2 bias_p_3 source_pmos source_pmos pmos W=1e-6 L=1e-6
M22 bias_p_3 net_1 source_nmos source_nmos nmos W=1e-6 L=1e-6
Cap_load_1 out source_nmos
.end symmetrical_op_amp_4271
