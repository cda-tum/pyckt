.suckt  symmetrical_op_amp_4233 ibias in1 in2 out source_nmos source_pmos
M1 out1fs in1 net_0 net_0 pmos W=25e-6 L=1e-6
M2 insourcetc in2 net_0 net_0 pmos W=25e-6 L=1e-6
M3 net_1 out1fs source_nmos source_nmos nmos W=33e-6 L=1e-6
M4 out1fs bias_n_1 net_1 net_1 nmos W=33e-6 L=1e-6
M5 net_2 insourcetc source_nmos source_nmos nmos W=1e-6 L=1e-6
M6 insourcetc bias_n_1 net_2 net_2 nmos W=1e-6 L=1e-6
M7 net_3 bias_p_2b source_pmos source_pmos pmos W=1e-6 L=1e-6
M8 net_0 ibias net_3 net_3 pmos W=1e-6 L=1e-6
M9 out instagebias source_pmos source_pmos pmos W=1e-6 L=1e-6
M10 net_6 out1fs source_nmos source_nmos nmos W=33e-6 L=1e-6
M11 out bias_n_1 net_6 net_6 nmos W=33e-6 L=1e-6
M12 net_7 insourcetc source_nmos source_nmos nmos W=1e-6 L=1e-6
M13 instagebias bias_n_1 net_7 net_7 nmos W=1e-6 L=1e-6
M14 instagebias instagebias source_pmos source_pmos pmos W=1e-6 L=1e-6
M15 bias_n_1 bias_n_1 source_nmos source_nmos nmos W=1e-6 L=1e-6
M16 bias_p_2b bias_p_2b source_pmos source_pmos pmos W=1e-6 L=1e-6
M17 ibias ibias bias_p_2b bias_p_2b pmos W=1e-6 L=1e-6
M18 bias_n_1 bias_p_2b source_pmos source_pmos pmos W=1e-6 L=1e-6
Cap_load_1 out source_nmos
.end symmetrical_op_amp_4233
