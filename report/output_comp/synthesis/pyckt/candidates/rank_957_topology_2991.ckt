.suckt  1stage_nmos_input ibias in1 in2 out source_nmos source_pmos
M1 net_0 in1 net_1 net_1 nmos W=31e-6 L=1e-6
M2 out in2 net_1 net_1 nmos W=31e-6 L=1e-6
M3 net_2 net_0 source_nmos source_nmos nmos W=8e-6 L=1e-6
M4 net_0 bias_n_1 net_2 net_2 nmos W=8e-6 L=1e-6
M5 net_4 net_0 source_nmos source_nmos nmos W=8e-6 L=1e-6
M6 out bias_n_1 net_4 net_4 nmos W=8e-6 L=1e-6
M7 net_5 bias_p_3b source_pmos source_pmos pmos W=6e-6 L=1e-6
M8 net_0 ibias net_5 net_5 pmos W=6e-6 L=1e-6
M9 net_8 bias_p_3b source_pmos source_pmos pmos W=6e-6 L=1e-6
M10 out ibias net_8 net_8 pmos W=6e-6 L=1e-6
M11 net_9 bias_n_2 source_nmos source_nmos nmos W=1e-6 L=1e-6
M12 net_1 bias_n_1 net_9 net_9 nmos W=1e-6 L=1e-6
M13 bias_n_1 bias_n_1 source_nmos source_nmos nmos W=1e-6 L=1e-6
M14 bias_n_2 bias_n_2 source_nmos source_nmos nmos W=1e-6 L=1e-6
M15 bias_p_3b bias_p_3b source_pmos source_pmos pmos W=6e-6 L=1e-6
M16 ibias ibias bias_p_3b bias_p_3b pmos W=6e-6 L=1e-6
M17 bias_n_2 bias_p_3b source_pmos source_pmos pmos W=6e-6 L=1e-6
M18 bias_n_1 bias_p_3b source_pmos source_pmos pmos W=6e-6 L=1e-6
Cap_load_1 out source_nmos
.end 1stage_nmos_input
