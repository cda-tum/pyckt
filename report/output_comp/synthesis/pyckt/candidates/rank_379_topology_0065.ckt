.suckt  2stage_pmos_input ibias in1 in2 out source_nmos source_pmos
M1 net_0 in1 net_1 net_1 pmos W=21e-6 L=1e-6
M2 outfirststage in2 net_1 net_1 pmos W=21e-6 L=1e-6
M3 net_2 net_2 source_nmos source_nmos nmos W=1e-6 L=1e-6
M4 net_0 net_0 net_2 net_2 nmos W=1e-6 L=1e-6
M5 net_3 net_2 source_nmos source_nmos nmos W=1e-6 L=1e-6
M6 outfirststage net_0 net_3 net_3 nmos W=1e-6 L=1e-6
M7 net_1 bias_p_3 source_pmos source_pmos pmos W=1e-6 L=1e-6
M8 net_5 outfirststage source_pmos source_pmos pmos W=1e-6 L=2e-6
M9 out bias_p_2 net_5 net_5 pmos W=4e-6 L=2e-6
M10 net_7 net_7 source_nmos source_nmos nmos W=4e-6 L=2e-6
M11 out ibias net_7 net_7 nmos W=4e-6 L=2e-6
M12 ibias ibias bias_n_1m bias_n_1m nmos W=4e-6 L=2e-6
M13 bias_n_1m net_7 source_nmos source_nmos nmos W=4e-6 L=2e-6
M14 bias_p_2 bias_p_2 source_pmos source_pmos pmos W=1e-6 L=29e-6
M15 bias_p_3 bias_p_3 source_pmos source_pmos pmos W=1e-6 L=1e-6
M16 bias_p_3 net_7 source_nmos source_nmos nmos W=4e-6 L=2e-6
M17 bias_p_2 net_7 source_nmos source_nmos nmos W=4e-6 L=2e-6
Cap_load_1 out source_nmos
Cap_compensation_1 outfirststage out
.end 2stage_pmos_input
