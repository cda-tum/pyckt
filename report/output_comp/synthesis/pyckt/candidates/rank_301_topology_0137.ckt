.suckt  2stage_nmos_input ibias in1 in2 out source_nmos source_pmos
M1 net_0 in1 net_1 net_1 nmos W=3e-6 L=1e-6
M2 outfirststage in2 net_1 net_1 nmos W=3e-6 L=1e-6
M3 net_0 net_2 source_pmos source_pmos pmos W=1e-6 L=1e-6
M4 net_2 net_2 source_pmos source_pmos pmos W=1e-6 L=1e-6
M5 outfirststage net_0 net_2 net_2 pmos W=1e-6 L=1e-6
M6 net_1 bias_n_2 source_nmos source_nmos nmos W=1e-6 L=1e-6
M7 net_4 net_4 source_pmos source_pmos pmos W=1e-6 L=1e-6
M8 out ibias net_4 net_4 pmos W=1e-6 L=1e-6
M9 net_6 outfirststage source_nmos source_nmos nmos W=1e-6 L=1e-6
M10 out bias_n_1 net_6 net_6 nmos W=4e-6 L=1e-6
M11 bias_n_1 bias_n_1 source_nmos source_nmos nmos W=1e-6 L=1e-6
M12 bias_n_2 bias_n_2 source_nmos source_nmos nmos W=1e-6 L=1e-6
M13 ibias ibias bias_p_3m bias_p_3m pmos W=1e-6 L=1e-6
M14 bias_p_3m net_4 source_pmos source_pmos pmos W=1e-6 L=1e-6
M15 bias_n_2 net_4 source_pmos source_pmos pmos W=1e-6 L=1e-6
M16 bias_n_1 net_4 source_pmos source_pmos pmos W=1e-6 L=1e-6
Cap_load_1 out source_nmos
Cap_compensation_1 outfirststage out
.end 2stage_nmos_input
