.suckt  2stage_pmos_input ibias in1 in2 out source_nmos source_pmos
M1 net_0 in1 net_1 net_1 pmos W=25e-6 L=1e-6
M2 outfirststage in2 net_1 net_1 pmos W=25e-6 L=1e-6
M3 net_0 net_0 source_pmos source_pmos pmos W=1e-6 L=6e-6
M4 net_2 net_0 source_pmos source_pmos pmos W=1e-6 L=6e-6
M5 outfirststage bias_p_4 net_2 net_2 pmos W=1e-6 L=6e-6
M6 net_0 ibias source_nmos source_nmos nmos W=1e-6 L=6e-6
M7 outfirststage ibias source_nmos source_nmos nmos W=1e-6 L=6e-6
M8 net_5 net_5 source_pmos source_pmos pmos W=1e-6 L=1e-6
M9 net_1 net_6 net_5 net_5 pmos W=1e-6 L=1e-6
M10 net_7 net_7 source_pmos source_pmos pmos W=1e-6 L=1e-6
M11 out net_8 net_7 net_7 pmos W=1e-6 L=1e-6
M12 out outfirststage source_nmos source_nmos nmos W=2e-6 L=1e-6
M13 ibias ibias source_nmos source_nmos nmos W=1e-6 L=6e-6
M14 net_6 net_6 bias_p_2m bias_p_2m pmos W=1e-6 L=1e-6
M15 bias_p_2m net_5 source_pmos source_pmos pmos W=1e-6 L=1e-6
M16 net_8 net_8 bias_p_3m bias_p_3m pmos W=1e-6 L=1e-6
M17 bias_p_3m net_7 source_pmos source_pmos pmos W=1e-6 L=1e-6
M18 bias_p_4 bias_p_4 source_pmos source_pmos pmos W=1e-6 L=21e-6
M19 net_8 ibias source_nmos source_nmos nmos W=1e-6 L=6e-6
M20 bias_p_4 ibias source_nmos source_nmos nmos W=1e-6 L=6e-6
M21 net_6 ibias source_nmos source_nmos nmos W=1e-6 L=6e-6
Cap_load_1 out source_nmos
Cap_compensation_1 outfirststage out
.end 2stage_pmos_input
