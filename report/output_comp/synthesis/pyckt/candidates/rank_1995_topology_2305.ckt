.suckt  2stage_pmos_input ibias in1 in2 out source_nmos source_pmos
M1 net_0 in1 net_1 net_1 pmos W=25e-6 L=1e-6
M2 outfirststage in2 net_1 net_1 pmos W=25e-6 L=1e-6
M3 net_0 net_0 source_pmos source_pmos pmos W=1e-6 L=12e-6
M4 outfirststage net_0 source_pmos source_pmos pmos W=1e-6 L=12e-6
M5 net_0 ibias source_nmos source_nmos nmos W=1e-6 L=1e-6
M6 outfirststage ibias source_nmos source_nmos nmos W=1e-6 L=1e-6
M7 net_3 net_3 source_pmos source_pmos pmos W=1e-6 L=1e-6
M8 net_1 net_4 net_3 net_3 pmos W=1e-6 L=1e-6
M9 net_5 bias_p_3b source_pmos source_pmos pmos W=1e-6 L=1e-6
M10 out bias_p_3t net_5 net_5 pmos W=1e-6 L=1e-6
M11 out outfirststage source_nmos source_nmos nmos W=3e-6 L=1e-6
M12 ibias ibias source_nmos source_nmos nmos W=1e-6 L=1e-6
M13 net_4 net_4 bias_p_2m bias_p_2m pmos W=1e-6 L=1e-6
M14 bias_p_2m net_3 source_pmos source_pmos pmos W=1e-6 L=1e-6
M15 bias_p_3b bias_p_3b source_pmos source_pmos pmos W=1e-6 L=1e-6
M16 bias_p_3t bias_p_3t bias_p_3b bias_p_3b pmos W=1e-6 L=1e-6
M17 bias_p_3t ibias source_nmos source_nmos nmos W=1e-6 L=1e-6
M18 net_4 ibias source_nmos source_nmos nmos W=1e-6 L=1e-6
Cap_load_1 out source_nmos
Cap_compensation_1 outfirststage out
.end 2stage_pmos_input
