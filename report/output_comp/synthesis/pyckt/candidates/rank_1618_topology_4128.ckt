.suckt  symmetrical_op_amp_4128 ibias in1 in2 out source_nmos source_pmos
M1 out1fs in1 net_0 net_0 pmos W=25e-6 L=1e-6
M2 out2fs in2 net_0 net_0 pmos W=25e-6 L=1e-6
M3 out1fs out1fs source_nmos source_nmos nmos W=1e-6 L=1e-6
M4 out2fs out2fs source_nmos source_nmos nmos W=1e-6 L=1e-6
M5 net_1 bias_p_2b source_pmos source_pmos pmos W=1e-6 L=1e-6
M6 net_0 ibias net_1 net_1 pmos W=1e-6 L=1e-6
M7 net_4 insourcestagebias source_pmos source_pmos pmos W=1e-6 L=1e-6
M8 out inoutputstagebias net_4 net_4 pmos W=1e-6 L=1e-6
M9 net_5 out1fs source_nmos source_nmos nmos W=1e-6 L=1e-6
M10 out bias_n_1 net_5 net_5 nmos W=10e-6 L=1e-6
M11 net_6 out2fs source_nmos source_nmos nmos W=1e-6 L=1e-6
M12 inoutputstagebias bias_n_1 net_6 net_6 nmos W=1e-6 L=1e-6
M13 insourcestagebias insourcestagebias source_pmos source_pmos pmos W=1e-6 L=1e-6
M14 inoutputstagebias inoutputstagebias insourcestagebias insourcestagebias pmos W=1e-6 L=1e-6
M15 bias_n_1 bias_n_1 source_nmos source_nmos nmos W=1e-6 L=1e-6
M16 bias_p_2b bias_p_2b source_pmos source_pmos pmos W=1e-6 L=1e-6
M17 ibias ibias bias_p_2b bias_p_2b pmos W=1e-6 L=1e-6
M18 bias_n_1 bias_p_2b source_pmos source_pmos pmos W=1e-6 L=1e-6
Cap_load_1 out source_nmos
.end symmetrical_op_amp_4128
