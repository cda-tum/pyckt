.suckt  symmetrical_op_amp_4235 ibias in1 in2 out source_nmos source_pmos
M1 out1fs in1 net_0 net_0 pmos W=25e-6 L=1e-6
M2 insourcetc in2 net_0 net_0 pmos W=25e-6 L=1e-6
M3 net_1 out1fs source_nmos source_nmos nmos W=3e-6 L=1e-6
M4 out1fs bias_n_1 net_1 net_1 nmos W=3e-6 L=1e-6
M5 net_2 insourcetc source_nmos source_nmos nmos W=1e-6 L=1e-6
M6 insourcetc bias_n_1 net_2 net_2 nmos W=1e-6 L=1e-6
M7 net_3 bias_p_2b source_pmos source_pmos pmos W=2e-6 L=1e-6
M8 net_0 ibias net_3 net_3 pmos W=2e-6 L=1e-6
M9 net_6 insourcestagebias source_pmos source_pmos pmos W=7e-6 L=1e-6
M10 out inoutputstagebias net_6 net_6 pmos W=7e-6 L=1e-6
M11 net_7 out1fs source_nmos source_nmos nmos W=3e-6 L=1e-6
M12 out bias_n_1 net_7 net_7 nmos W=3e-6 L=1e-6
M13 net_8 insourcetc source_nmos source_nmos nmos W=1e-6 L=1e-6
M14 inoutputstagebias bias_n_1 net_8 net_8 nmos W=1e-6 L=1e-6
M15 insourcestagebias insourcestagebias source_pmos source_pmos pmos W=7e-6 L=1e-6
M16 inoutputstagebias inoutputstagebias insourcestagebias insourcestagebias pmos W=7e-6 L=1e-6
M17 bias_n_1 bias_n_1 source_nmos source_nmos nmos W=1e-6 L=1e-6
M18 bias_p_2b bias_p_2b source_pmos source_pmos pmos W=2e-6 L=1e-6
M19 ibias ibias bias_p_2b bias_p_2b pmos W=2e-6 L=1e-6
M20 bias_n_1 bias_p_2b source_pmos source_pmos pmos W=2e-6 L=1e-6
Cap_load_1 out source_nmos
.end symmetrical_op_amp_4235
