.suckt  symmetrical_op_amp_4114 ibias in1 in2 out source_nmos source_pmos
M1 out1fs in1 net_0 net_0 nmos W=664e-6 L=1e-6
M2 out2fs in2 net_0 net_0 nmos W=664e-6 L=1e-6
M3 out1fs out1fs source_pmos source_pmos pmos W=1e-6 L=1e-6
M4 out2fs out2fs source_pmos source_pmos pmos W=1e-6 L=1e-6
M5 net_0 ibias source_nmos source_nmos nmos W=1e-6 L=1e-6
M6 net_2 out1fs source_pmos source_pmos pmos W=1e-6 L=1e-6
M7 out bias_p_2 net_2 net_2 pmos W=19e-6 L=1e-6
M8 out instagebias source_nmos source_nmos nmos W=1e-6 L=1e-6
M9 net_3 out2fs source_pmos source_pmos pmos W=1e-6 L=1e-6
M10 instagebias bias_p_2 net_3 net_3 pmos W=1e-6 L=1e-6
M11 instagebias instagebias source_nmos source_nmos nmos W=1e-6 L=1e-6
M12 ibias ibias source_nmos source_nmos nmos W=1e-6 L=1e-6
M13 bias_p_2 bias_p_2 source_pmos source_pmos pmos W=1e-6 L=23e-6
M14 bias_p_2 ibias source_nmos source_nmos nmos W=1e-6 L=1e-6
Cap_load_1 out source_nmos
.end symmetrical_op_amp_4114
