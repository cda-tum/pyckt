.suckt  2stage_nmos_input ibias in1 in2 out source_nmos source_pmos
M1 net_0 in1 net_1 net_1 nmos W=4e-6 L=1e-6
M2 outfirststage in2 net_1 net_1 nmos W=4e-6 L=1e-6
M3 net_0 net_0 source_nmos source_nmos nmos W=1e-6 L=3e-6
M4 outfirststage net_0 source_nmos source_nmos nmos W=1e-6 L=3e-6
M5 net_0 ibias source_pmos source_pmos pmos W=1e-6 L=3e-6
M6 outfirststage ibias source_pmos source_pmos pmos W=1e-6 L=3e-6
M7 net_3 bias_n_2b source_nmos source_nmos nmos W=1e-6 L=1e-6
M8 net_1 bias_n_2t net_3 net_3 nmos W=1e-6 L=1e-6
M9 out outfirststage source_pmos source_pmos pmos W=4e-6 L=1e-6
M10 net_6 net_6 source_nmos source_nmos nmos W=2e-6 L=1e-6
M11 out net_7 net_6 net_6 nmos W=2e-6 L=1e-6
M12 net_7 net_7 bias_n_1m bias_n_1m nmos W=2e-6 L=1e-6
M13 bias_n_1m net_6 source_nmos source_nmos nmos W=2e-6 L=1e-6
M14 bias_n_2b bias_n_2b source_nmos source_nmos nmos W=1e-6 L=1e-6
M15 bias_n_2t bias_n_2t bias_n_2b bias_n_2b nmos W=1e-6 L=1e-6
M16 ibias ibias source_pmos source_pmos pmos W=1e-6 L=3e-6
M17 bias_n_2t ibias source_pmos source_pmos pmos W=1e-6 L=3e-6
M18 net_7 ibias source_pmos source_pmos pmos W=1e-6 L=3e-6
Cap_load_1 out source_nmos
Cap_compensation_1 outfirststage out
.end 2stage_nmos_input
