.suckt  symmetrical_op_amp_4220 ibias in1 in2 out source_nmos source_pmos
M1 out2fs in1 net_0 net_0 pmos W=21e-6 L=1e-6
M2 inoutputtc in2 net_0 net_0 pmos W=21e-6 L=1e-6
M3 out1fs out1fs source_nmos source_nmos nmos W=2e-6 L=1e-6
M4 out2fs out2fs out1fs out1fs nmos W=2e-6 L=1e-6
M5 insourcetc insourcetc source_nmos source_nmos nmos W=1e-6 L=1e-6
M6 inoutputtc inoutputtc insourcetc insourcetc nmos W=1e-6 L=1e-6
M7 net_1 ibias source_pmos source_pmos pmos W=1e-6 L=1e-6
M8 net_0 bias_p_1 net_1 net_1 pmos W=2e-6 L=1e-6
M9 net_4 instagebias source_pmos source_pmos pmos W=1e-6 L=1e-6
M10 out bias_p_1 net_4 net_4 pmos W=17e-6 L=1e-6
M11 net_6 out1fs source_nmos source_nmos nmos W=2e-6 L=1e-6
M12 out out2fs net_6 net_6 nmos W=2e-6 L=1e-6
M13 net_7 insourcetc source_nmos source_nmos nmos W=1e-6 L=1e-6
M14 instagebias inoutputtc net_7 net_7 nmos W=1e-6 L=1e-6
M15 instagebias instagebias source_pmos source_pmos pmos W=1e-6 L=1e-6
M16 bias_p_1 bias_p_1 source_pmos source_pmos pmos W=1e-6 L=10e-6
M17 ibias ibias source_pmos source_pmos pmos W=1e-6 L=1e-6
M18 bias_n_3 bias_n_3 source_nmos source_nmos nmos W=1e-6 L=1e-6
M19 bias_p_1 bias_n_3 source_nmos source_nmos nmos W=1e-6 L=1e-6
M20 bias_n_3 ibias source_pmos source_pmos pmos W=1e-6 L=1e-6
Cap_load_1 out source_nmos
.end symmetrical_op_amp_4220
