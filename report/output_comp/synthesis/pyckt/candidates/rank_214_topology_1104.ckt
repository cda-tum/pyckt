.suckt  2stage_nmos_input ibias in1 in2 out source_nmos source_pmos
M1 net_0 in1 net_1 net_1 nmos W=10e-6 L=1e-6
M2 net_2 in2 net_1 net_1 nmos W=10e-6 L=1e-6
M3 net_0 bias_p_3 source_pmos source_pmos pmos W=1e-6 L=1e-6
M4 net_4 bias_p_2 net_0 net_0 pmos W=10e-6 L=1e-6
M5 net_2 bias_p_3 source_pmos source_pmos pmos W=1e-6 L=1e-6
M6 outfirststage bias_p_2 net_2 net_2 pmos W=10e-6 L=1e-6
M7 net_4 net_6 source_nmos source_nmos nmos W=1e-6 L=1e-6
M8 net_6 net_6 source_nmos source_nmos nmos W=1e-6 L=1e-6
M9 outfirststage net_4 net_6 net_6 nmos W=1e-6 L=1e-6
M10 net_7 bias_n_1b source_nmos source_nmos nmos W=3e-6 L=1e-6
M11 net_1 ibias net_7 net_7 nmos W=3e-6 L=1e-6
M12 net_10 outfirststage source_pmos source_pmos pmos W=1e-6 L=1e-6
M13 out bias_p_2 net_10 net_10 pmos W=8e-6 L=1e-6
M14 net_12 bias_n_1b source_nmos source_nmos nmos W=3e-6 L=1e-6
M15 out ibias net_12 net_12 nmos W=3e-6 L=1e-6
M16 bias_n_1b bias_n_1b source_nmos source_nmos nmos W=3e-6 L=1e-6
M17 ibias ibias bias_n_1b bias_n_1b nmos W=3e-6 L=1e-6
M18 bias_p_2 bias_p_2 source_pmos source_pmos pmos W=1e-6 L=11e-6
M19 bias_p_3 bias_p_3 source_pmos source_pmos pmos W=1e-6 L=1e-6
M20 bias_p_3 bias_n_1b source_nmos source_nmos nmos W=3e-6 L=1e-6
M21 bias_p_2 bias_n_1b source_nmos source_nmos nmos W=3e-6 L=1e-6
Cap_load_1 out source_nmos
Cap_compensation_1 outfirststage out
.end 2stage_nmos_input
