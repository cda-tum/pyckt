.suckt  1stage_pmos_input ibias in1 in2 out source_nmos source_pmos
M1 net_0 in1 net_1 net_1 pmos W=25e-6 L=1e-6
M2 out in2 net_1 net_1 pmos W=25e-6 L=1e-6
M3 net_2 net_0 source_pmos source_pmos pmos W=13e-6 L=2e-6
M4 net_0 bias_p_3 net_2 net_2 pmos W=13e-6 L=2e-6
M5 net_4 net_0 source_pmos source_pmos pmos W=13e-6 L=2e-6
M6 out bias_p_3 net_4 net_4 pmos W=13e-6 L=2e-6
M7 net_0 ibias source_nmos source_nmos nmos W=1e-6 L=2e-6
M8 out ibias source_nmos source_nmos nmos W=1e-6 L=2e-6
M9 net_6 net_6 source_pmos source_pmos pmos W=2e-6 L=1e-6
M10 net_1 net_7 net_6 net_6 pmos W=2e-6 L=1e-6
M11 ibias ibias source_nmos source_nmos nmos W=1e-6 L=2e-6
M12 net_7 net_7 bias_p_2m bias_p_2m pmos W=2e-6 L=1e-6
M13 bias_p_2m net_6 source_pmos source_pmos pmos W=2e-6 L=1e-6
M14 bias_p_3 bias_p_3 source_pmos source_pmos pmos W=1e-6 L=22e-6
M15 net_7 ibias source_nmos source_nmos nmos W=1e-6 L=2e-6
M16 bias_p_3 ibias source_nmos source_nmos nmos W=1e-6 L=2e-6
Cap_load_1 out source_nmos
.end 1stage_pmos_input
