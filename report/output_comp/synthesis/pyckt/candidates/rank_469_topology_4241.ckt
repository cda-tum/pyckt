.suckt  symmetrical_op_amp_4241 ibias in1 in2 out source_nmos source_pmos
M1 out1fs in1 net_0 net_0 pmos W=26e-6 L=1e-6
M2 insourcetc in2 net_0 net_0 pmos W=26e-6 L=1e-6
M3 net_1 out1fs source_nmos source_nmos nmos W=3e-6 L=1e-6
M4 out1fs bias_n_1 net_1 net_1 nmos W=3e-6 L=1e-6
M5 net_2 insourcetc source_nmos source_nmos nmos W=1e-6 L=1e-6
M6 insourcetc bias_n_1 net_2 net_2 nmos W=1e-6 L=1e-6
M7 net_3 net_3 source_pmos source_pmos pmos W=1e-6 L=1e-6
M8 net_0 ibias net_3 net_3 pmos W=1e-6 L=1e-6
M9 net_5 instagebias source_pmos source_pmos pmos W=1e-6 L=1e-6
M10 out bias_p_3 net_5 net_5 pmos W=11e-6 L=1e-6
M11 net_7 out1fs source_nmos source_nmos nmos W=3e-6 L=1e-6
M12 out bias_n_1 net_7 net_7 nmos W=3e-6 L=1e-6
M13 net_8 insourcetc source_nmos source_nmos nmos W=1e-6 L=1e-6
M14 instagebias bias_n_1 net_8 net_8 nmos W=1e-6 L=1e-6
M15 instagebias instagebias source_pmos source_pmos pmos W=1e-6 L=1e-6
M16 bias_n_1 bias_n_1 source_nmos source_nmos nmos W=1e-6 L=1e-6
M17 ibias ibias bias_p_2m bias_p_2m pmos W=1e-6 L=1e-6
M18 bias_p_2m net_3 source_pmos source_pmos pmos W=1e-6 L=1e-6
M19 bias_p_3 bias_p_3 source_pmos source_pmos pmos W=1e-6 L=15e-6
M20 bias_n_4 bias_n_4 source_nmos source_nmos nmos W=1e-6 L=1e-6
M21 bias_n_1 net_3 source_pmos source_pmos pmos W=1e-6 L=1e-6
M22 bias_p_3 bias_n_4 source_nmos source_nmos nmos W=1e-6 L=1e-6
M23 bias_n_4 net_3 source_pmos source_pmos pmos W=1e-6 L=1e-6
Cap_load_1 out source_nmos
.end symmetrical_op_amp_4241
