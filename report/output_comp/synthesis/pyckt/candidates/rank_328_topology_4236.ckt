.suckt  symmetrical_op_amp_4236 ibias in1 in2 out source_nmos source_pmos
M1 out1fs in1 net_0 net_0 pmos W=22e-6 L=1e-6
M2 insourcetc in2 net_0 net_0 pmos W=22e-6 L=1e-6
M3 net_1 out1fs source_nmos source_nmos nmos W=34e-6 L=1e-6
M4 out1fs bias_n_1 net_1 net_1 nmos W=34e-6 L=1e-6
M5 net_2 insourcetc source_nmos source_nmos nmos W=3e-6 L=1e-6
M6 insourcetc bias_n_1 net_2 net_2 nmos W=3e-6 L=1e-6
M7 net_3 ibias source_pmos source_pmos pmos W=1e-6 L=1e-6
M8 net_0 bias_p_2 net_3 net_3 pmos W=1e-6 L=2e-6
M9 net_6 insourcestagebias source_pmos source_pmos pmos W=11e-6 L=1e-6
M10 out bias_p_2 net_6 net_6 pmos W=11e-6 L=1e-6
M11 net_7 out1fs source_nmos source_nmos nmos W=34e-6 L=1e-6
M12 out bias_n_1 net_7 net_7 nmos W=34e-6 L=1e-6
M13 net_8 insourcetc source_nmos source_nmos nmos W=3e-6 L=1e-6
M14 insourcestagebias bias_n_1 net_8 net_8 nmos W=3e-6 L=1e-6
M15 net_9 insourcestagebias source_pmos source_pmos pmos W=11e-6 L=1e-6
M16 insourcestagebias bias_p_2 net_9 net_9 pmos W=11e-6 L=1e-6
M17 bias_n_1 bias_n_1 source_nmos source_nmos nmos W=1e-6 L=1e-6
M18 bias_p_2 bias_p_2 source_pmos source_pmos pmos W=1e-6 L=6e-6
M19 ibias ibias source_pmos source_pmos pmos W=1e-6 L=1e-6
M20 bias_n_4 bias_n_4 source_nmos source_nmos nmos W=1e-6 L=1e-6
M21 bias_n_1 ibias source_pmos source_pmos pmos W=1e-6 L=1e-6
M22 bias_p_2 bias_n_4 source_nmos source_nmos nmos W=1e-6 L=1e-6
M23 bias_n_4 ibias source_pmos source_pmos pmos W=1e-6 L=1e-6
Cap_load_1 out source_nmos
.end symmetrical_op_amp_4236
