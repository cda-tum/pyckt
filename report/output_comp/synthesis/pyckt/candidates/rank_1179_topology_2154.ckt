.suckt  2stage_nmos_input ibias in1 in2 out source_nmos source_pmos
M1 net_0 in1 net_1 net_1 nmos W=3e-6 L=1e-6
M2 outfirststage in2 net_1 net_1 nmos W=3e-6 L=1e-6
M3 net_0 net_2 source_nmos source_nmos nmos W=1e-6 L=1e-6
M4 net_2 net_2 source_nmos source_nmos nmos W=1e-6 L=1e-6
M5 outfirststage net_0 net_2 net_2 nmos W=1e-6 L=1e-6
M6 net_3 bias_p_3b source_pmos source_pmos pmos W=1e-6 L=1e-6
M7 net_0 ibias net_3 net_3 pmos W=1e-6 L=1e-6
M8 net_6 bias_p_3b source_pmos source_pmos pmos W=1e-6 L=1e-6
M9 outfirststage ibias net_6 net_6 pmos W=1e-6 L=1e-6
M10 net_1 bias_n_2 source_nmos source_nmos nmos W=1e-6 L=1e-6
M11 out outfirststage source_pmos source_pmos pmos W=1e-6 L=1e-6
M12 net_8 bias_n_2 source_nmos source_nmos nmos W=1e-6 L=1e-6
M13 out bias_n_1 net_8 net_8 nmos W=2e-6 L=1e-6
M14 bias_n_1 bias_n_1 source_nmos source_nmos nmos W=1e-6 L=1e-6
M15 bias_n_2 bias_n_2 source_nmos source_nmos nmos W=1e-6 L=1e-6
M16 bias_p_3b bias_p_3b source_pmos source_pmos pmos W=1e-6 L=1e-6
M17 ibias ibias bias_p_3b bias_p_3b pmos W=1e-6 L=1e-6
M18 bias_n_2 bias_p_3b source_pmos source_pmos pmos W=1e-6 L=1e-6
M19 bias_n_1 bias_p_3b source_pmos source_pmos pmos W=1e-6 L=1e-6
Cap_load_1 out source_nmos
Cap_compensation_1 outfirststage out
.end 2stage_nmos_input
