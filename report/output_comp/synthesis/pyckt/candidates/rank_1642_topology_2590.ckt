.suckt  2stage_pmos_input ibias in1 in2 out source_nmos source_pmos
M1 net_0 in1 net_1 net_1 pmos W=25e-6 L=1e-6
M2 outfirststage in2 net_1 net_1 pmos W=25e-6 L=1e-6
M3 net_2 net_0 source_pmos source_pmos pmos W=1e-6 L=6e-6
M4 net_0 bias_p_4 net_2 net_2 pmos W=1e-6 L=6e-6
M5 net_4 net_0 source_pmos source_pmos pmos W=1e-6 L=6e-6
M6 outfirststage bias_p_4 net_4 net_4 pmos W=1e-6 L=6e-6
M7 net_5 ibias source_nmos source_nmos nmos W=1e-6 L=6e-6
M8 net_0 bias_n_1 net_5 net_5 nmos W=1e-6 L=1e-6
M9 net_8 ibias source_nmos source_nmos nmos W=1e-6 L=6e-6
M10 outfirststage bias_n_1 net_8 net_8 nmos W=1e-6 L=6e-6
M11 net_9 net_9 source_pmos source_pmos pmos W=1e-6 L=1e-6
M12 net_1 net_10 net_9 net_9 pmos W=1e-6 L=1e-6
M13 out bias_p_5 source_pmos source_pmos pmos W=1e-6 L=1e-6
M14 net_12 outfirststage source_nmos source_nmos nmos W=1e-6 L=1e-6
M15 out bias_n_1 net_12 net_12 nmos W=42e-6 L=1e-6
M16 bias_n_1 bias_n_1 source_nmos source_nmos nmos W=1e-6 L=1e-6
M17 ibias ibias source_nmos source_nmos nmos W=1e-6 L=6e-6
M18 net_10 net_10 bias_p_3m bias_p_3m pmos W=1e-6 L=1e-6
M19 bias_p_3m net_9 source_pmos source_pmos pmos W=1e-6 L=1e-6
M20 bias_p_4 bias_p_4 source_pmos source_pmos pmos W=1e-6 L=12e-6
M21 bias_p_5 bias_p_5 source_pmos source_pmos pmos W=1e-6 L=1e-6
M22 bias_p_5 ibias source_nmos source_nmos nmos W=1e-6 L=6e-6
M23 bias_n_1 bias_p_5 source_pmos source_pmos pmos W=1e-6 L=1e-6
M24 bias_p_4 ibias source_nmos source_nmos nmos W=1e-6 L=6e-6
M25 net_10 ibias source_nmos source_nmos nmos W=1e-6 L=6e-6
Cap_load_1 out source_nmos
Cap_compensation_1 outfirststage out
.end 2stage_pmos_input
