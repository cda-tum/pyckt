.suckt  2stage_nmos_input ibias in1 in2 out source_nmos source_pmos
M1 net_0 in1 net_1 net_1 nmos W=4e-6 L=1e-6
M2 outfirststage in2 net_1 net_1 nmos W=4e-6 L=1e-6
M3 net_0 net_0 source_nmos source_nmos nmos W=1e-6 L=2e-6
M4 net_2 net_0 source_nmos source_nmos nmos W=1e-6 L=2e-6
M5 outfirststage bias_n_2 net_2 net_2 nmos W=1e-6 L=2e-6
M6 net_0 ibias source_pmos source_pmos pmos W=1e-6 L=2e-6
M7 outfirststage ibias source_pmos source_pmos pmos W=1e-6 L=2e-6
M8 net_1 bias_n_3 source_nmos source_nmos nmos W=1e-6 L=1e-6
M9 net_6 outfirststage source_pmos source_pmos pmos W=1e-6 L=1e-6
M10 out bias_p_4 net_6 net_6 pmos W=7e-6 L=1e-6
M11 net_8 net_8 source_nmos source_nmos nmos W=2e-6 L=1e-6
M12 out net_9 net_8 net_8 nmos W=2e-6 L=1e-6
M13 net_9 net_9 bias_n_1m bias_n_1m nmos W=2e-6 L=1e-6
M14 bias_n_1m net_8 source_nmos source_nmos nmos W=2e-6 L=1e-6
M15 bias_n_2 bias_n_2 source_nmos source_nmos nmos W=1e-6 L=1e-6
M16 bias_n_3 bias_n_3 source_nmos source_nmos nmos W=1e-6 L=1e-6
M17 bias_p_4 bias_p_4 source_pmos source_pmos pmos W=1e-6 L=14e-6
M18 ibias ibias source_pmos source_pmos pmos W=1e-6 L=2e-6
M19 bias_n_3 ibias source_pmos source_pmos pmos W=1e-6 L=2e-6
M20 bias_n_2 ibias source_pmos source_pmos pmos W=1e-6 L=2e-6
M21 bias_p_4 bias_n_3 source_nmos source_nmos nmos W=1e-6 L=1e-6
M22 net_9 ibias source_pmos source_pmos pmos W=1e-6 L=2e-6
Cap_load_1 out source_nmos
Cap_compensation_1 outfirststage out
.end 2stage_nmos_input
