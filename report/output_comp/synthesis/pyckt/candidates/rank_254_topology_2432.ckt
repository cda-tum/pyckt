.suckt  1stage_pmos_input ibias in1 in2 out source_nmos source_pmos
M1 net_0 in1 net_1 net_1 pmos W=25e-6 L=1e-6
M2 out in2 net_1 net_1 pmos W=25e-6 L=1e-6
M3 net_0 net_2 source_pmos source_pmos pmos W=1e-6 L=1e-6
M4 net_2 net_2 source_pmos source_pmos pmos W=1e-6 L=1e-6
M5 out net_0 net_2 net_2 pmos W=1e-6 L=1e-6
M6 net_3 bias_n_1b source_nmos source_nmos nmos W=1e-6 L=1e-6
M7 net_0 bias_n_1t net_3 net_3 nmos W=1e-6 L=1e-6
M8 net_6 bias_n_1b source_nmos source_nmos nmos W=1e-6 L=1e-6
M9 out bias_n_1t net_6 net_6 nmos W=1e-6 L=1e-6
M10 net_7 net_7 source_pmos source_pmos pmos W=1e-6 L=1e-6
M11 net_1 ibias net_7 net_7 pmos W=1e-6 L=1e-6
M12 bias_n_1b bias_n_1b source_nmos source_nmos nmos W=1e-6 L=1e-6
M13 bias_n_1t bias_n_1t bias_n_1b bias_n_1b nmos W=1e-6 L=1e-6
M14 ibias ibias bias_p_2m bias_p_2m pmos W=1e-6 L=1e-6
M15 bias_p_2m net_7 source_pmos source_pmos pmos W=1e-6 L=1e-6
M16 bias_n_1t net_7 source_pmos source_pmos pmos W=1e-6 L=1e-6
Cap_load_1 out source_nmos
.end 1stage_pmos_input
