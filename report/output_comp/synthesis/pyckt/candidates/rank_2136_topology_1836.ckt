.suckt  2stage_nmos_input ibias in1 in2 out source_nmos source_pmos
M1 net_0 in1 net_1 net_1 nmos W=6e-6 L=1e-6
M2 net_2 in2 net_1 net_1 nmos W=6e-6 L=1e-6
M3 net_3 net_4 net_0 net_0 nmos W=6e-6 L=1e-6
M4 outfirststage net_4 net_2 net_2 nmos W=6e-6 L=1e-6
M5 net_5 net_6 source_pmos source_pmos pmos W=1e-6 L=1e-6
M6 net_3 net_3 net_5 net_5 pmos W=1e-6 L=1e-6
M7 net_6 net_6 source_pmos source_pmos pmos W=1e-6 L=1e-6
M8 outfirststage net_3 net_6 net_6 pmos W=1e-6 L=1e-6
M9 net_7 net_7 source_nmos source_nmos nmos W=1e-6 L=1e-6
M10 net_1 net_8 net_7 net_7 nmos W=1e-6 L=1e-6
M11 out ibias source_pmos source_pmos pmos W=1e-6 L=1e-6
M12 net_10 outfirststage source_nmos source_nmos nmos W=1e-6 L=1e-6
M13 out bias_n_2 net_10 net_10 nmos W=4e-6 L=1e-6
M14 net_4 net_4 net_1 net_1 nmos W=1e-6 L=1e-6
M15 net_8 net_8 bias_n_1m bias_n_1m nmos W=1e-6 L=1e-6
M16 bias_n_1m net_7 source_nmos source_nmos nmos W=1e-6 L=1e-6
M17 bias_n_2 bias_n_2 source_nmos source_nmos nmos W=1e-6 L=1e-6
M18 ibias ibias source_pmos source_pmos pmos W=1e-6 L=1e-6
M19 net_8 ibias source_pmos source_pmos pmos W=1e-6 L=1e-6
M20 net_4 ibias source_pmos source_pmos pmos W=1e-6 L=1e-6
M21 bias_n_2 ibias source_pmos source_pmos pmos W=1e-6 L=1e-6
Cap_load_1 out source_nmos
Cap_compensation_1 outfirststage out
.end 2stage_nmos_input
