.suckt  2stage_pmos_input ibias in1 in2 out source_nmos source_pmos
M1 net_0 in1 net_1 net_1 pmos W=25e-6 L=1e-6
M2 outfirststage in2 net_1 net_1 pmos W=25e-6 L=1e-6
M3 net_2 net_2 source_pmos source_pmos pmos W=1e-6 L=1e-6
M4 net_0 net_0 net_2 net_2 pmos W=1e-6 L=1e-6
M5 net_3 net_2 source_pmos source_pmos pmos W=1e-6 L=1e-6
M6 outfirststage net_0 net_3 net_3 pmos W=1e-6 L=1e-6
M7 net_4 bias_n_1b source_nmos source_nmos nmos W=1e-6 L=1e-6
M8 net_0 ibias net_4 net_4 nmos W=1e-6 L=1e-6
M9 net_7 bias_n_1b source_nmos source_nmos nmos W=1e-6 L=1e-6
M10 outfirststage ibias net_7 net_7 nmos W=1e-6 L=1e-6
M11 net_8 net_8 source_pmos source_pmos pmos W=1e-6 L=1e-6
M12 net_1 net_9 net_8 net_8 pmos W=1e-6 L=1e-6
M13 net_10 net_10 source_pmos source_pmos pmos W=1e-6 L=1e-6
M14 out net_11 net_10 net_10 pmos W=1e-6 L=1e-6
M15 out outfirststage source_nmos source_nmos nmos W=2e-6 L=1e-6
M16 bias_n_1b bias_n_1b source_nmos source_nmos nmos W=1e-6 L=1e-6
M17 ibias ibias bias_n_1b bias_n_1b nmos W=1e-6 L=1e-6
M18 net_9 net_9 bias_p_2m bias_p_2m pmos W=1e-6 L=1e-6
M19 bias_p_2m net_8 source_pmos source_pmos pmos W=1e-6 L=1e-6
M20 net_11 net_11 bias_p_3m bias_p_3m pmos W=1e-6 L=1e-6
M21 bias_p_3m net_10 source_pmos source_pmos pmos W=1e-6 L=1e-6
M22 net_11 bias_n_1b source_nmos source_nmos nmos W=1e-6 L=1e-6
M23 net_9 bias_n_1b source_nmos source_nmos nmos W=1e-6 L=1e-6
Cap_load_1 out source_nmos
Cap_compensation_1 outfirststage out
.end 2stage_pmos_input
