.suckt  1stage_pmos_input ibias in1 in2 out source_nmos source_pmos
M1 net_0 in1 net_1 net_1 pmos W=25e-6 L=1e-6
M2 out in2 net_1 net_1 pmos W=25e-6 L=1e-6
M3 net_2 net_3 source_nmos source_nmos nmos W=1e-6 L=1e-6
M4 net_0 net_0 net_2 net_2 nmos W=1e-6 L=1e-6
M5 net_3 net_3 source_nmos source_nmos nmos W=1e-6 L=1e-6
M6 out net_0 net_3 net_3 nmos W=1e-6 L=1e-6
M7 net_4 bias_p_1b source_pmos source_pmos pmos W=1e-6 L=1e-6
M8 net_1 ibias net_4 net_4 pmos W=1e-6 L=1e-6
M9 bias_p_1b bias_p_1b source_pmos source_pmos pmos W=1e-6 L=1e-6
M10 ibias ibias bias_p_1b bias_p_1b pmos W=1e-6 L=1e-6
Cap_load_1 out source_nmos
.end 1stage_pmos_input
