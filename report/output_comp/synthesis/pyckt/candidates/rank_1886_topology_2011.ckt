.suckt  2stage_pmos_input ibias in1 in2 out source_nmos source_pmos
M1 net_0 in1 net_1 net_1 pmos W=15e-6 L=1e-6
M2 outfirststage in2 net_1 net_1 pmos W=15e-6 L=1e-6
M3 net_2 net_0 source_pmos source_pmos pmos W=1e-6 L=3e-6
M4 net_0 bias_p_3 net_2 net_2 pmos W=1e-6 L=3e-6
M5 net_4 net_0 source_pmos source_pmos pmos W=1e-6 L=3e-6
M6 outfirststage bias_p_3 net_4 net_4 pmos W=1e-6 L=3e-6
M7 net_0 bias_n_2 source_nmos source_nmos nmos W=1e-6 L=3e-6
M8 outfirststage bias_n_2 source_nmos source_nmos nmos W=1e-6 L=3e-6
M9 net_1 ibias source_pmos source_pmos pmos W=1e-6 L=1e-6
M10 out outfirststage source_pmos source_pmos pmos W=2e-6 L=3e-6
M11 net_7 bias_n_2 source_nmos source_nmos nmos W=1e-6 L=3e-6
M12 out bias_n_1 net_7 net_7 nmos W=4e-6 L=3e-6
M13 bias_n_1 bias_n_1 source_nmos source_nmos nmos W=1e-6 L=1e-6
M14 bias_n_2 bias_n_2 source_nmos source_nmos nmos W=1e-6 L=3e-6
M15 bias_p_3 bias_p_3 source_pmos source_pmos pmos W=1e-6 L=10e-6
M16 ibias ibias source_pmos source_pmos pmos W=1e-6 L=1e-6
M17 bias_n_2 ibias source_pmos source_pmos pmos W=1e-6 L=1e-6
M18 bias_n_1 ibias source_pmos source_pmos pmos W=1e-6 L=1e-6
M19 bias_p_3 bias_n_2 source_nmos source_nmos nmos W=1e-6 L=3e-6
Cap_load_1 out source_nmos
Cap_compensation_1 outfirststage out
.end 2stage_pmos_input
