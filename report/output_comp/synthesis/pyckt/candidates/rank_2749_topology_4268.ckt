.suckt  symmetrical_op_amp_4268 ibias in1 in2 out source_nmos source_pmos
M1 out2fs in1 net_0 net_0 nmos W=669e-6 L=1e-6
M2 inoutputtc in2 net_0 net_0 nmos W=669e-6 L=1e-6
M3 out1fs out1fs source_pmos source_pmos pmos W=7e-6 L=1e-6
M4 out2fs out2fs out1fs out1fs pmos W=7e-6 L=1e-6
M5 insourcetc insourcetc source_pmos source_pmos pmos W=1e-6 L=2e-6
M6 inoutputtc inoutputtc insourcetc insourcetc pmos W=1e-6 L=2e-6
M7 net_1 net_1 source_nmos source_nmos nmos W=1e-6 L=1e-6
M8 net_0 ibias net_1 net_1 nmos W=1e-6 L=1e-6
M9 net_3 out1fs source_pmos source_pmos pmos W=7e-6 L=1e-6
M10 out out2fs net_3 net_3 pmos W=7e-6 L=1e-6
M11 out instagebias source_nmos source_nmos nmos W=1e-6 L=1e-6
M12 net_4 insourcetc source_pmos source_pmos pmos W=1e-6 L=2e-6
M13 instagebias inoutputtc net_4 net_4 pmos W=1e-6 L=2e-6
M14 instagebias instagebias source_nmos source_nmos nmos W=1e-6 L=1e-6
M15 ibias ibias bias_n_1m bias_n_1m nmos W=1e-6 L=1e-6
M16 bias_n_1m net_1 source_nmos source_nmos nmos W=1e-6 L=1e-6
Cap_load_1 out source_nmos
.end symmetrical_op_amp_4268
