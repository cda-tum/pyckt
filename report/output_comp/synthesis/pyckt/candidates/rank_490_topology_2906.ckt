.suckt  2stage_nmos_input ibias in1 in2 out source_nmos source_pmos
M1 net_0 in1 net_1 net_1 nmos W=4e-6 L=1e-6
M2 outfirststage in2 net_1 net_1 nmos W=4e-6 L=1e-6
M3 net_0 net_0 source_nmos source_nmos nmos W=1e-6 L=1e-6
M4 net_2 net_0 source_nmos source_nmos nmos W=1e-6 L=1e-6
M5 outfirststage bias_n_2 net_2 net_2 nmos W=1e-6 L=1e-6
M6 net_4 bias_p_4b source_pmos source_pmos pmos W=1e-6 L=1e-6
M7 net_0 bias_p_4t net_4 net_4 pmos W=1e-6 L=1e-6
M8 net_7 bias_p_4b source_pmos source_pmos pmos W=1e-6 L=1e-6
M9 outfirststage bias_p_4t net_7 net_7 pmos W=1e-6 L=1e-6
M10 net_8 net_8 source_nmos source_nmos nmos W=1e-6 L=1e-6
M11 net_1 ibias net_8 net_8 nmos W=1e-6 L=1e-6
M12 net_10 net_10 source_pmos source_pmos pmos W=1e-6 L=1e-6
M13 out net_11 net_10 net_10 pmos W=1e-6 L=1e-6
M14 net_12 outfirststage source_nmos source_nmos nmos W=1e-6 L=1e-6
M15 out bias_n_2 net_12 net_12 nmos W=30e-6 L=1e-6
M16 ibias ibias bias_n_1m bias_n_1m nmos W=1e-6 L=1e-6
M17 bias_n_1m net_8 source_nmos source_nmos nmos W=1e-6 L=1e-6
M18 bias_n_2 bias_n_2 source_nmos source_nmos nmos W=1e-6 L=1e-6
M19 net_11 net_11 bias_p_3m bias_p_3m pmos W=1e-6 L=1e-6
M20 bias_p_3m net_10 source_pmos source_pmos pmos W=1e-6 L=1e-6
M21 bias_p_4b bias_p_4b source_pmos source_pmos pmos W=1e-6 L=1e-6
M22 bias_p_4t bias_p_4t bias_p_4b bias_p_4b pmos W=1e-6 L=1e-6
M23 bias_p_4t net_8 source_nmos source_nmos nmos W=1e-6 L=1e-6
M24 bias_n_2 bias_p_4b source_pmos source_pmos pmos W=1e-6 L=1e-6
M25 net_11 net_8 source_nmos source_nmos nmos W=1e-6 L=1e-6
Cap_load_1 out source_nmos
Cap_compensation_1 outfirststage out
.end 2stage_nmos_input
