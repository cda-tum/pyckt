.suckt  2stage_pmos_input ibias in1 in2 out source_nmos source_pmos
M1 net_0 in1 net_1 net_1 pmos W=25e-6 L=1e-6
M2 outfirststage in2 net_1 net_1 pmos W=25e-6 L=1e-6
M3 net_2 net_3 source_nmos source_nmos nmos W=1e-6 L=1e-6
M4 net_0 net_0 net_2 net_2 nmos W=1e-6 L=1e-6
M5 net_3 net_3 source_nmos source_nmos nmos W=1e-6 L=1e-6
M6 outfirststage net_0 net_3 net_3 nmos W=1e-6 L=1e-6
M7 net_4 net_4 source_pmos source_pmos pmos W=1e-6 L=1e-6
M8 net_1 net_5 net_4 net_4 pmos W=1e-6 L=1e-6
M9 net_6 bias_p_3b source_pmos source_pmos pmos W=1e-6 L=1e-6
M10 out ibias net_6 net_6 pmos W=1e-6 L=1e-6
M11 net_9 outfirststage source_nmos source_nmos nmos W=1e-6 L=1e-6
M12 out bias_n_1 net_9 net_9 nmos W=7e-6 L=1e-6
M13 bias_n_1 bias_n_1 source_nmos source_nmos nmos W=1e-6 L=1e-6
M14 net_5 net_5 bias_p_2m bias_p_2m pmos W=1e-6 L=1e-6
M15 bias_p_2m net_4 source_pmos source_pmos pmos W=1e-6 L=1e-6
M16 bias_p_3b bias_p_3b source_pmos source_pmos pmos W=1e-6 L=1e-6
M17 ibias ibias bias_p_3b bias_p_3b pmos W=1e-6 L=1e-6
M18 bias_n_4 bias_n_4 source_nmos source_nmos nmos W=1e-6 L=1e-6
M19 bias_n_1 bias_p_3b source_pmos source_pmos pmos W=1e-6 L=1e-6
M20 net_5 bias_n_4 source_nmos source_nmos nmos W=1e-6 L=1e-6
M21 bias_n_4 bias_p_3b source_pmos source_pmos pmos W=1e-6 L=1e-6
Cap_load_1 out source_nmos
Cap_compensation_1 outfirststage out
.end 2stage_pmos_input
