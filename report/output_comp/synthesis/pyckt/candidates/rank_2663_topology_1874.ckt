.suckt  2stage_pmos_input ibias in1 in2 out source_nmos source_pmos
M1 net_0 in1 net_1 net_1 pmos W=32e-6 L=1e-6
M2 outfirststage in2 net_1 net_1 pmos W=32e-6 L=1e-6
M3 net_0 net_0 source_pmos source_pmos pmos W=1e-6 L=12e-6
M4 outfirststage net_0 source_pmos source_pmos pmos W=1e-6 L=12e-6
M5 net_0 bias_n_1 source_nmos source_nmos nmos W=1e-6 L=1e-6
M6 outfirststage bias_n_1 source_nmos source_nmos nmos W=1e-6 L=1e-6
M7 net_1 ibias source_pmos source_pmos pmos W=6e-6 L=1e-6
M8 out ibias source_pmos source_pmos pmos W=6e-6 L=1e-6
M9 out outfirststage source_nmos source_nmos nmos W=2e-6 L=1e-6
M10 bias_n_1 bias_n_1 source_nmos source_nmos nmos W=1e-6 L=1e-6
M11 ibias ibias source_pmos source_pmos pmos W=6e-6 L=1e-6
M12 bias_n_1 ibias source_pmos source_pmos pmos W=6e-6 L=1e-6
Cap_load_1 out source_nmos
Cap_compensation_1 outfirststage out
.end 2stage_pmos_input
