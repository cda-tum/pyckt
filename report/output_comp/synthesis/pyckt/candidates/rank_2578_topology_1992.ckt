.suckt  2stage_pmos_input ibias in1 in2 out source_nmos source_pmos
M1 net_0 in1 net_1 net_1 pmos W=30e-6 L=1e-6
M2 outfirststage in2 net_1 net_1 pmos W=30e-6 L=1e-6
M3 net_2 net_2 source_pmos source_pmos pmos W=1e-6 L=1e-6
M4 net_0 net_0 net_2 net_2 pmos W=1e-6 L=1e-6
M5 net_3 net_2 source_pmos source_pmos pmos W=1e-6 L=1e-6
M6 outfirststage net_0 net_3 net_3 pmos W=1e-6 L=1e-6
M7 net_4 bias_n_2 source_nmos source_nmos nmos W=1e-6 L=1e-6
M8 net_0 bias_n_1 net_4 net_4 nmos W=1e-6 L=1e-6
M9 net_7 bias_n_2 source_nmos source_nmos nmos W=1e-6 L=1e-6
M10 outfirststage bias_n_1 net_7 net_7 nmos W=1e-6 L=1e-6
M11 net_1 ibias source_pmos source_pmos pmos W=6e-6 L=1e-6
M12 out ibias source_pmos source_pmos pmos W=6e-6 L=1e-6
M13 net_10 outfirststage source_nmos source_nmos nmos W=1e-6 L=1e-6
M14 out bias_n_1 net_10 net_10 nmos W=33e-6 L=1e-6
M15 bias_n_1 bias_n_1 source_nmos source_nmos nmos W=1e-6 L=1e-6
M16 bias_n_2 bias_n_2 source_nmos source_nmos nmos W=1e-6 L=1e-6
M17 ibias ibias source_pmos source_pmos pmos W=6e-6 L=1e-6
M18 bias_n_2 ibias source_pmos source_pmos pmos W=6e-6 L=1e-6
M19 bias_n_1 ibias source_pmos source_pmos pmos W=6e-6 L=1e-6
Cap_load_1 out source_nmos
Cap_compensation_1 outfirststage out
.end 2stage_pmos_input
